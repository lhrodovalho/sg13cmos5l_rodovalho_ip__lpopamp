* NGSPICE file created from lpopamp_flat.ext - technology: ihp-sg13g2

.subckt lpopamp_flat in_m in_p out avdd avss ib en
X0 lpopamp_core_0.sliceB_1.bpb lpopamp_core_0.sliceB_1.bpb lpopamp_core_0.sliceB_1.bpa_l avdd sg13_hv_pmos ad=1.125p pd=5u as=1.125p ps=5u w=4.5u l=0.5u
X1 lpopamp_core_0.sliceA_0.yp_p lpopamp_core_0.sliceA_0.zp_m avdd avdd sg13_hv_pmos ad=1.125p pd=5u as=1.125p ps=5u w=4.5u l=3.5u
X2 a_8650_14850# lpopamp_core_0.sliceA_1.bna_ a_8550_14850# avss sg13_hv_nmos ad=1.125p pd=5u as=1.125p ps=5u w=4.5u l=0.5u
X3 a_21650_7150# lpopamp_core_0.sliceB_0.bna a_20050_6550# avss sg13_hv_nmos ad=1.125p pd=5u as=1.125p ps=5u w=4.5u l=3.5u
X4 lpopamp_core_0.sliceB_1.yp_m in_p a_13750_7800# avss sg13_hv_nmos ad=1.125p pd=5u as=1.125p ps=5u w=4.5u l=0.5u
X5 a_9550_100# lpopamp_core_0.sliceA_0.bnb lpopamp_core_0.sliceA_0.bnb avss sg13_hv_nmos ad=1.125p pd=5u as=1.125p ps=5u w=4.5u l=0.5u
X6 out zn_p a_28950_7150# avss sg13_hv_nmos ad=1.125p pd=5u as=1.125p ps=5u w=4.5u l=0.5u
X7 lpopamp_core_0.sliceA_1.bnb lpopamp_core_0.sliceA_1.bnb a_10550_14250# avss sg13_hv_nmos ad=1.125p pd=5u as=1.125p ps=5u w=4.5u l=0.5u
X8 a_25750_14250# lpopamp_core_0.sliceA_1.zn_m lpopamp_core_0.sliceA_1.yn_m avss sg13_hv_nmos ad=1.125p pd=5u as=1.125p ps=5u w=4.5u l=0.5u
X9 a_23850_10200# lpopamp_core_0.sliceB_1.bpb lpopamp_core_0.sliceB_1.zn_m avdd sg13_hv_pmos ad=1.125p pd=5u as=1.125p ps=5u w=4.5u l=0.5u
X10 a_10550_7800# lpopamp_core_0.sliceB_1.bnb lpopamp_core_0.sliceB_1.bna_ avss sg13_hv_nmos ad=1.125p pd=5u as=1.125p ps=5u w=4.5u l=0.5u
X11 a_29750_700# zn_p avss avss sg13_hv_nmos ad=1.125p pd=5u as=1.125p ps=5u w=4.5u l=0.5u
X12 a_14550_14250# in_p lpopamp_core_0.sliceA_1.xn avss sg13_hv_nmos ad=1.125p pd=5u as=1.125p ps=5u w=4.5u l=0.5u
X13 lpopamp_core_0.sliceB_0.yp_m lpopamp_core_0.sliceB_0.zp_m avdd avdd sg13_hv_pmos ad=1.125p pd=5u as=1.125p ps=5u w=4.5u l=3.5u
X14 lpopamp_core_0.sliceB_0.xp in_p lpopamp_core_0.sliceB_0.yn_m avdd sg13_hv_pmos ad=1.125p pd=5u as=1.125p ps=5u w=4.5u l=0.5u
X15 avss zn_p a_29550_14250# avss sg13_hv_nmos ad=1.125p pd=5u as=1.125p ps=5u w=4.5u l=0.5u
X16 lpopamp_core_0.sliceB_1.yn_m in_p lpopamp_core_0.sliceB_1.xp avdd sg13_hv_pmos ad=1.125p pd=5u as=1.125p ps=5u w=4.5u l=0.5u
X17 a_12650_6550# lpopamp_core_0.sliceB_0.bna_ a_12550_6550# avss sg13_hv_nmos ad=1.125p pd=5u as=1.125p ps=5u w=4.5u l=0.5u
X18 out zp_p avdd avdd sg13_hv_pmos ad=1.125p pd=5u as=1.125p ps=5u w=4.5u l=0.5u
X19 lpopamp_core_0.sliceB_0.bpa_r lpopamp_core_0.sliceB_0.bpb lpopamp_core_0.sliceB_0.bpb avdd sg13_hv_pmos ad=1.125p pd=5u as=1.125p ps=5u w=4.5u l=0.5u
X20 lpopamp_core_0.sliceB_0.yn_p in_m lpopamp_core_0.sliceB_0.xp avdd sg13_hv_pmos ad=1.125p pd=5u as=1.125p ps=5u w=4.5u l=0.5u
X21 a_11050_12450# lpopamp_core_0.sliceA_1.bpa_r a_10950_12450# avdd sg13_hv_pmos ad=1.125p pd=5u as=1.125p ps=5u w=4.5u l=0.5u
X22 zp_p lpopamp_core_0.sliceA_1.zp_m lpopamp_core_0.sliceA_1.yp_m avdd sg13_hv_pmos ad=1.125p pd=5u as=1.125p ps=5u w=4.5u l=0.5u
X23 a_20950_7800# lpopamp_core_0.sliceB_1.bnb a_20050_7800# avss sg13_hv_nmos ad=1.125p pd=5u as=1.125p ps=5u w=4.5u l=0.5u
X24 avdd lpopamp_core_0.sliceA_0.bpa a_22450_2500# avdd sg13_hv_pmos ad=1.125p pd=5u as=1.125p ps=5u w=4.5u l=3.5u
X25 zn_p lpopamp_core_0.sliceB_0.bpb zp_p avdd sg13_hv_pmos ad=1.125p pd=5u as=1.125p ps=5u w=4.5u l=0.5u
X26 lpopamp_core_0.sliceA_1.zp_m lpopamp_core_0.sliceA_1.zp_m lpopamp_core_0.sliceA_1.yp_p avdd sg13_hv_pmos ad=1.125p pd=5u as=1.125p ps=5u w=4.5u l=0.5u
X27 a_4050_700# lpopamp_core_0.sliceA_0.bna lpopamp_core_0.sliceA_0.bna avss sg13_hv_nmos ad=1.125p pd=5u as=1.125p ps=5u w=4.5u l=3.5u
X28 lpopamp_core_0.sliceA_0.bpa_l lpopamp_core_0.sliceA_0.bpb lpopamp_core_0.sliceA_0.bpb avdd sg13_hv_pmos ad=1.125p pd=5u as=1.125p ps=5u w=4.5u l=0.5u
X29 out zn_p a_28550_7800# avss sg13_hv_nmos ad=1.125p pd=5u as=1.125p ps=5u w=4.5u l=0.5u
X30 lpopamp_core_0.sliceA_0.xn in_p a_14750_700# avss sg13_hv_nmos ad=1.125p pd=5u as=1.125p ps=5u w=4.5u l=0.5u
X31 lpopamp_core_0.sliceB_1.bpb lpopamp_core_0.sliceB_1.bpb lpopamp_core_0.sliceB_1.bpa_l avdd sg13_hv_pmos ad=1.125p pd=5u as=1.125p ps=5u w=4.5u l=0.5u
X32 lpopamp_core_0.sliceB_0.bpb lpopamp_core_0.sliceB_0.bna a_6850_6550# avss sg13_hv_nmos ad=1.125p pd=5u as=1.125p ps=5u w=4.5u l=3.5u
X33 lpopamp_core_0.sliceA_1.bnb lpopamp_core_0.sliceA_1.bnb a_9350_14250# avss sg13_hv_nmos ad=1.125p pd=5u as=1.125p ps=5u w=4.5u l=0.5u
X34 lpopamp_core_0.sliceA_0.xp lpopamp_core_0.sliceA_0.bpa avdd avdd sg13_hv_pmos ad=1.125p pd=5u as=1.125p ps=5u w=4.5u l=3.5u
X35 lpopamp_core_0.sliceB_0.zn_m lpopamp_core_0.sliceB_0.bpb a_23850_4150# avdd sg13_hv_pmos ad=1.125p pd=5u as=1.125p ps=5u w=4.5u l=0.5u
X36 avdd en lpopamp_core_0.sliceB_0.bpa avdd sg13_hv_pmos ad=1.125p pd=5u as=1.125p ps=5u w=4.5u l=1.5u
X37 lpopamp_core_0.sliceB_0.bpa_l lpopamp_core_0.sliceB_0.bpb lpopamp_core_0.sliceB_0.bpb avdd sg13_hv_pmos ad=1.125p pd=5u as=1.125p ps=5u w=4.5u l=0.5u
X38 lpopamp_core_0.sliceB_1.yn_m lpopamp_core_0.sliceB_1.zn_m a_25250_7800# avss sg13_hv_nmos ad=1.125p pd=5u as=1.125p ps=5u w=4.5u l=3.5u
X39 lpopamp_core_0.sliceB_1.bna_ lpopamp_core_0.sliceB_1.bnb a_9150_7800# avss sg13_hv_nmos ad=1.125p pd=5u as=1.125p ps=5u w=4.5u l=0.5u
X40 lpopamp_core_0.sliceA_0.yp_m in_p a_14950_100# avss sg13_hv_nmos ad=1.125p pd=5u as=1.125p ps=5u w=4.5u l=0.5u
X41 out zp_p avdd avdd sg13_hv_pmos ad=1.125p pd=5u as=1.125p ps=5u w=4.5u l=0.5u
X42 zn_p lpopamp_core_0.sliceA_1.enb avss avss sg13_hv_nmos ad=1.125p pd=5u as=1.125p ps=5u w=4.5u l=1.5u
X43 a_10950_11850# lpopamp_core_0.sliceA_1.bpa_r lpopamp_core_0.sliceA_1.bpa_r avdd sg13_hv_pmos ad=1.125p pd=5u as=1.125p ps=5u w=4.5u l=0.5u
X44 a_24450_700# lpopamp_core_0.sliceA_0.zn_m lpopamp_core_0.sliceA_0.yn_p avss sg13_hv_nmos ad=1.125p pd=5u as=1.125p ps=5u w=4.5u l=3.5u
X45 lpopamp_core_0.sliceA_0.zn_m lpopamp_core_0.sliceA_0.zn_m a_23750_100# avss sg13_hv_nmos ad=1.125p pd=5u as=1.125p ps=5u w=4.5u l=0.5u
X46 zn_p lpopamp_core_0.sliceB_0.zn_m a_27350_6550# avss sg13_hv_nmos ad=1.125p pd=5u as=1.125p ps=5u w=4.5u l=0.5u
X47 a_22450_10200# lpopamp_core_0.sliceB_1.bpb lpopamp_core_0.sliceB_1.zn_m avdd sg13_hv_pmos ad=1.125p pd=5u as=1.125p ps=5u w=4.5u l=0.5u
X48 a_23950_14850# lpopamp_core_0.sliceA_1.zn_m lpopamp_core_0.sliceA_1.zn_m avss sg13_hv_nmos ad=1.125p pd=5u as=1.125p ps=5u w=4.5u l=0.5u
X49 out zp_p a_29850_11850# avdd sg13_hv_pmos ad=1.125p pd=5u as=1.125p ps=5u w=4.5u l=0.5u
X50 a_11150_2500# lpopamp_core_0.sliceA_0.bpa_r a_11050_2500# avdd sg13_hv_pmos ad=1.125p pd=5u as=1.125p ps=5u w=4.5u l=0.5u
X51 a_9150_4150# lpopamp_core_0.sliceB_0.bpa_r a_9050_4150# avdd sg13_hv_pmos ad=1.125p pd=5u as=1.125p ps=5u w=4.5u l=0.5u
X52 a_12750_14850# lpopamp_core_0.sliceA_1.bna_ a_12650_14850# avss sg13_hv_nmos ad=1.125p pd=5u as=1.125p ps=5u w=4.5u l=0.5u
X53 lpopamp_core_0.sliceA_1.yn_m in_p lpopamp_core_0.sliceA_1.xp avdd sg13_hv_pmos ad=1.125p pd=5u as=1.125p ps=5u w=4.5u l=0.5u
X54 a_24450_6550# lpopamp_core_0.sliceB_0.zn_m lpopamp_core_0.sliceB_0.yn_p avss sg13_hv_nmos ad=1.125p pd=5u as=1.125p ps=5u w=4.5u l=3.5u
X55 lpopamp_core_0.sliceB_1.yp_p lpopamp_core_0.sliceB_1.zp_m avdd avdd sg13_hv_pmos ad=1.125p pd=5u as=1.125p ps=5u w=4.5u l=3.5u
X56 a_8750_2500# lpopamp_core_0.sliceA_0.bpa_l a_8650_2500# avdd sg13_hv_pmos ad=1.125p pd=5u as=1.125p ps=5u w=4.5u l=0.5u
X57 a_12550_8400# lpopamp_core_0.sliceB_1.bna_ a_12450_8400# avss sg13_hv_nmos ad=1.125p pd=5u as=1.125p ps=5u w=4.5u l=0.5u
X58 a_5250_100# lpopamp_core_0.sliceA_0.bna avss avss sg13_hv_nmos ad=1.125p pd=5u as=1.125p ps=5u w=4.5u l=3.5u
X59 lpopamp_core_0.sliceA_0.zp_m lpopamp_core_0.sliceA_0.zp_m lpopamp_core_0.sliceA_0.yp_p avdd sg13_hv_pmos ad=1.125p pd=5u as=1.125p ps=5u w=4.5u l=0.5u
X60 a_4050_14850# lpopamp_core_0.sliceA_1.bna lpopamp_core_0.sliceA_1.bna avss sg13_hv_nmos ad=1.125p pd=5u as=1.125p ps=5u w=4.5u l=3.5u
X61 lpopamp_core_0.sliceA_1.bpb lpopamp_core_0.sliceA_1.bpb lpopamp_core_0.sliceA_1.bpa_r avdd sg13_hv_pmos ad=1.125p pd=5u as=1.125p ps=5u w=4.5u l=0.5u
X62 lpopamp_core_0.sliceB_0.yp_p in_m a_14550_7150# avss sg13_hv_nmos ad=1.125p pd=5u as=1.125p ps=5u w=4.5u l=0.5u
X63 avdd zp_p out avdd sg13_hv_pmos ad=1.125p pd=5u as=1.125p ps=5u w=4.5u l=0.5u
X64 lpopamp_core_0.sliceA_0.enb en avdd avdd sg13_hv_pmos ad=1.125p pd=5u as=2.25p ps=10u w=4.5u l=1.5u
X65 lpopamp_core_0.sliceA_0.yn_m lpopamp_core_0.sliceA_0.zn_m a_25250_100# avss sg13_hv_nmos ad=1.125p pd=5u as=1.125p ps=5u w=4.5u l=3.5u
X66 a_11350_7150# lpopamp_core_0.sliceB_0.bnb lpopamp_core_0.sliceB_0.bna_ avss sg13_hv_nmos ad=1.125p pd=5u as=1.125p ps=5u w=4.5u l=0.5u
X67 a_20050_14250# lpopamp_core_0.sliceA_1.bnb a_20750_14250# avss sg13_hv_nmos ad=1.125p pd=5u as=1.125p ps=5u w=4.5u l=0.5u
X68 a_22950_8400# lpopamp_core_0.sliceB_1.zn_m lpopamp_core_0.sliceB_1.yn_p avss sg13_hv_nmos ad=1.125p pd=5u as=1.125p ps=5u w=4.5u l=0.5u
X69 zp_p lpopamp_core_0.sliceB_1.zp_m lpopamp_core_0.sliceB_1.yp_m avdd sg13_hv_pmos ad=1.125p pd=5u as=1.125p ps=5u w=4.5u l=0.5u
X70 out zn_p a_28550_14250# avss sg13_hv_nmos ad=1.125p pd=5u as=1.125p ps=5u w=4.5u l=0.5u
X71 lpopamp_core_0.sliceB_1.xp lpopamp_core_0.sliceB_1.bpa avdd avdd sg13_hv_pmos ad=1.125p pd=5u as=1.125p ps=5u w=4.5u l=3.5u
X72 lpopamp_core_0.sliceB_1.bna en ib avss sg13_hv_nmos ad=1.125p pd=5u as=1.125p ps=5u w=4.5u l=1.5u
X73 a_8950_7150# lpopamp_core_0.sliceB_0.bnb lpopamp_core_0.sliceB_0.bna_ avss sg13_hv_nmos ad=1.125p pd=5u as=1.125p ps=5u w=4.5u l=0.5u
X74 lpopamp_core_0.sliceA_0.zp_m lpopamp_core_0.sliceA_0.zp_m lpopamp_core_0.sliceA_0.yp_p avdd sg13_hv_pmos ad=1.125p pd=5u as=1.125p ps=5u w=4.5u l=0.5u
X75 a_27350_8400# lpopamp_core_0.sliceB_1.zn_m lpopamp_core_0.sliceB_1.yn_m avss sg13_hv_nmos ad=1.125p pd=5u as=1.125p ps=5u w=4.5u l=0.5u
X76 lpopamp_core_0.sliceA_1.yp_p lpopamp_core_0.sliceA_1.zp_m lpopamp_core_0.sliceA_1.zp_m avdd sg13_hv_pmos ad=1.125p pd=5u as=1.125p ps=5u w=4.5u l=0.5u
X77 avss lpopamp_core_0.sliceB_0.bna a_21650_7150# avss sg13_hv_nmos ad=1.125p pd=5u as=1.125p ps=5u w=4.5u l=3.5u
X78 lpopamp_core_0.sliceA_1.bpa_r lpopamp_core_0.sliceA_1.bpb lpopamp_core_0.sliceA_1.bpb avdd sg13_hv_pmos ad=1.125p pd=5u as=1.125p ps=5u w=4.5u l=0.5u
X79 lpopamp_core_0.sliceB_1.yn_p lpopamp_core_0.sliceB_1.zn_m a_23950_8400# avss sg13_hv_nmos ad=1.125p pd=5u as=1.125p ps=5u w=4.5u l=0.5u
X80 lpopamp_core_0.sliceA_0.bna_ lpopamp_core_0.sliceA_0.bnb a_10350_100# avss sg13_hv_nmos ad=1.125p pd=5u as=1.125p ps=5u w=4.5u l=0.5u
X81 out zn_p a_29350_7150# avss sg13_hv_nmos ad=1.125p pd=5u as=1.125p ps=5u w=4.5u l=0.5u
X82 a_10950_7800# lpopamp_core_0.sliceB_1.bnb lpopamp_core_0.sliceB_1.bna_ avss sg13_hv_nmos ad=1.125p pd=5u as=1.125p ps=5u w=4.5u l=0.5u
X83 avss en lpopamp_core_0.sliceB_0.enb avss sg13_hv_nmos ad=1.125p pd=5u as=1.125p ps=5u w=4.5u l=1.5u
X84 zn_p lpopamp_core_0.sliceA_0.bnb a_26550_700# avss sg13_hv_nmos ad=1.125p pd=5u as=1.125p ps=5u w=4.5u l=0.5u
X85 lpopamp_core_0.sliceA_1.bna lpopamp_core_0.sliceA_1.enb avss avss sg13_hv_nmos ad=1.125p pd=5u as=1.125p ps=5u w=4.5u l=1.5u
X86 avdd lpopamp_core_0.sliceA_1.bpa lpopamp_core_0.sliceA_1.xp avdd sg13_hv_pmos ad=1.125p pd=5u as=1.125p ps=5u w=4.5u l=3.5u
X87 avdd zp_p out avdd sg13_hv_pmos ad=1.125p pd=5u as=1.125p ps=5u w=4.5u l=0.5u
X88 a_26150_7150# lpopamp_core_0.sliceB_0.zn_m lpopamp_core_0.sliceB_0.yn_m avss sg13_hv_nmos ad=1.125p pd=5u as=1.125p ps=5u w=4.5u l=0.5u
X89 lpopamp_core_0.sliceB_1.bpb lpopamp_core_0.sliceB_1.bpb lpopamp_core_0.sliceB_1.bpa_l avdd sg13_hv_pmos ad=1.125p pd=5u as=1.125p ps=5u w=4.5u l=0.5u
X90 a_8450_14250# lpopamp_core_0.sliceA_1.bna_ a_8350_14250# avss sg13_hv_nmos ad=1.125p pd=5u as=1.125p ps=5u w=4.5u l=0.5u
X91 a_15650_7800# lpopamp_core_0.sliceB_1.bna lpopamp_core_0.sliceB_1.xn avss sg13_hv_nmos ad=1.125p pd=5u as=1.125p ps=5u w=4.5u l=3.5u
X92 lpopamp_core_0.sliceB_0.bpa_r lpopamp_core_0.sliceB_0.bpb lpopamp_core_0.sliceB_0.bpb avdd sg13_hv_pmos ad=1.125p pd=5u as=1.125p ps=5u w=4.5u l=0.5u
X93 lpopamp_core_0.sliceA_1.yp_p lpopamp_core_0.sliceA_1.zp_m lpopamp_core_0.sliceA_1.zp_m avdd sg13_hv_pmos ad=1.125p pd=5u as=1.125p ps=5u w=4.5u l=0.5u
X94 lpopamp_core_0.sliceB_0.yn_p in_m lpopamp_core_0.sliceB_0.xp avdd sg13_hv_pmos ad=1.125p pd=5u as=1.125p ps=5u w=4.5u l=0.5u
X95 a_11050_4750# lpopamp_core_0.sliceB_0.bpa_r a_10950_4750# avdd sg13_hv_pmos ad=1.125p pd=5u as=1.125p ps=5u w=4.5u l=0.5u
X96 lpopamp_core_0.sliceB_1.bna_ lpopamp_core_0.sliceB_1.bnb a_11950_7800# avss sg13_hv_nmos ad=1.125p pd=5u as=1.125p ps=5u w=4.5u l=0.5u
X97 lpopamp_core_0.sliceB_1.yp_p lpopamp_core_0.sliceB_1.zp_m lpopamp_core_0.sliceB_1.zp_m avdd sg13_hv_pmos ad=1.125p pd=5u as=1.125p ps=5u w=4.5u l=0.5u
X98 a_22950_14850# lpopamp_core_0.sliceA_1.zn_m lpopamp_core_0.sliceA_1.yn_p avss sg13_hv_nmos ad=1.125p pd=5u as=1.125p ps=5u w=4.5u l=0.5u
X99 out zp_p avdd avdd sg13_hv_pmos ad=1.125p pd=5u as=1.125p ps=5u w=4.5u l=0.5u
X100 lpopamp_core_0.sliceB_1.bpa_r lpopamp_core_0.sliceB_1.bpb lpopamp_core_0.sliceB_1.bpb avdd sg13_hv_pmos ad=1.125p pd=5u as=1.125p ps=5u w=4.5u l=0.5u
X101 avss lpopamp_core_0.sliceA_0.bna a_7650_700# avss sg13_hv_nmos ad=1.125p pd=5u as=1.125p ps=5u w=4.5u l=3.5u
X102 a_23850_2500# lpopamp_core_0.sliceA_0.bpa avdd avdd sg13_hv_pmos ad=1.125p pd=5u as=1.125p ps=5u w=4.5u l=3.5u
X103 lpopamp_core_0.sliceA_0.bpa_l lpopamp_core_0.sliceA_0.bpb lpopamp_core_0.sliceA_0.bpb avdd sg13_hv_pmos ad=1.125p pd=5u as=1.125p ps=5u w=4.5u l=0.5u
X104 a_11750_14850# lpopamp_core_0.sliceA_1.bnb lpopamp_core_0.sliceA_1.bna_ avss sg13_hv_nmos ad=1.125p pd=5u as=1.125p ps=5u w=4.5u l=0.5u
X105 lpopamp_core_0.sliceA_1.bpb lpopamp_core_0.sliceA_1.bpb lpopamp_core_0.sliceA_1.bpa_r avdd sg13_hv_pmos ad=1.125p pd=5u as=1.125p ps=5u w=4.5u l=0.5u
X106 lpopamp_core_0.sliceA_1.xp lpopamp_core_0.sliceA_1.bpa avdd avdd sg13_hv_pmos ad=1.125p pd=5u as=1.125p ps=5u w=4.5u l=3.5u
X107 zp_p lpopamp_core_0.sliceB_1.zp_m lpopamp_core_0.sliceB_1.yp_m avdd sg13_hv_pmos ad=1.125p pd=5u as=1.125p ps=5u w=4.5u l=0.5u
X108 a_14150_6550# in_p lpopamp_core_0.sliceB_0.xn avss sg13_hv_nmos ad=1.125p pd=5u as=1.125p ps=5u w=4.5u l=0.5u
X109 zp_p lpopamp_core_0.sliceA_1.bnb a_26750_14850# avss sg13_hv_nmos ad=1.125p pd=5u as=1.125p ps=5u w=4.5u l=0.5u
X110 a_11750_700# lpopamp_core_0.sliceA_0.bnb lpopamp_core_0.sliceA_0.bna_ avss sg13_hv_nmos ad=1.125p pd=5u as=1.125p ps=5u w=4.5u l=0.5u
X111 a_29450_10800# zp_p out avdd sg13_hv_pmos ad=1.125p pd=5u as=1.125p ps=5u w=4.5u l=0.5u
X112 lpopamp_core_0.sliceA_0.yp_p lpopamp_core_0.sliceA_0.zp_m lpopamp_core_0.sliceA_0.zp_m avdd sg13_hv_pmos ad=1.125p pd=5u as=1.125p ps=5u w=4.5u l=0.5u
X113 a_8650_4750# lpopamp_core_0.sliceB_0.bpa_l a_8550_4750# avdd sg13_hv_pmos ad=1.125p pd=5u as=1.125p ps=5u w=4.5u l=0.5u
X114 a_25750_7800# lpopamp_core_0.sliceB_1.zn_m lpopamp_core_0.sliceB_1.yn_m avss sg13_hv_nmos ad=1.125p pd=5u as=1.125p ps=5u w=4.5u l=0.5u
X115 lpopamp_core_0.sliceB_1.bna_ lpopamp_core_0.sliceB_1.bnb a_9550_7800# avss sg13_hv_nmos ad=1.125p pd=5u as=1.125p ps=5u w=4.5u l=0.5u
X116 lpopamp_core_0.sliceB_1.xp in_m lpopamp_core_0.sliceB_1.yn_p avdd sg13_hv_pmos ad=1.125p pd=5u as=1.125p ps=5u w=4.5u l=0.5u
X117 out zp_p avdd avdd sg13_hv_pmos ad=1.125p pd=5u as=1.125p ps=5u w=4.5u l=0.5u
X118 lpopamp_core_0.sliceB_0.yp_p lpopamp_core_0.sliceB_0.zp_m lpopamp_core_0.sliceB_0.zp_m avdd sg13_hv_pmos ad=1.125p pd=5u as=1.125p ps=5u w=4.5u l=0.5u
X119 avss lpopamp_core_0.sliceA_0.zn_m a_28050_700# avss sg13_hv_nmos ad=1.125p pd=5u as=1.125p ps=5u w=4.5u l=3.5u
X120 a_20750_100# lpopamp_core_0.sliceA_0.bnb lpopamp_core_0.sliceA_0.zp_m avss sg13_hv_nmos ad=1.125p pd=5u as=1.125p ps=5u w=4.5u l=0.5u
X121 avdd lpopamp_core_0.sliceB_0.bpa lpopamp_core_0.sliceB_0.bpa avdd sg13_hv_pmos ad=1.125p pd=5u as=1.125p ps=5u w=4.5u l=3.5u
X122 lpopamp_core_0.sliceA_0.zp_m lpopamp_core_0.sliceA_0.bnb a_20950_700# avss sg13_hv_nmos ad=1.125p pd=5u as=1.125p ps=5u w=4.5u l=0.5u
X123 out zp_p avdd avdd sg13_hv_pmos ad=1.125p pd=5u as=1.125p ps=5u w=4.5u l=0.5u
X124 zn_p lpopamp_core_0.sliceB_0.bpb zp_p avdd sg13_hv_pmos ad=1.125p pd=5u as=1.125p ps=5u w=4.5u l=0.5u
X125 lpopamp_core_0.sliceB_0.bpb lpopamp_core_0.sliceB_0.bpb lpopamp_core_0.sliceB_0.bpa_r avdd sg13_hv_pmos ad=1.125p pd=5u as=1.125p ps=5u w=4.5u l=0.5u
X126 avss lpopamp_core_0.sliceB_0.zn_m a_24450_6550# avss sg13_hv_nmos ad=1.125p pd=5u as=1.125p ps=5u w=4.5u l=3.5u
X127 a_8750_11850# lpopamp_core_0.sliceA_1.bpa_l a_8650_11850# avdd sg13_hv_pmos ad=1.125p pd=5u as=1.125p ps=5u w=4.5u l=0.5u
X128 a_8450_6550# lpopamp_core_0.sliceB_0.bna_ a_8350_6550# avss sg13_hv_nmos ad=1.125p pd=5u as=1.125p ps=5u w=4.5u l=0.5u
X129 avdd lpopamp_core_0.sliceB_1.bpa lpopamp_core_0.sliceB_1.bpa avdd sg13_hv_pmos ad=1.125p pd=5u as=1.125p ps=5u w=4.5u l=3.5u
X130 avss zn_p a_29950_100# avss sg13_hv_nmos ad=1.125p pd=5u as=1.125p ps=5u w=4.5u l=0.5u
X131 a_20050_6550# lpopamp_core_0.sliceB_0.bnb a_21150_6550# avss sg13_hv_nmos ad=1.125p pd=5u as=1.125p ps=5u w=4.5u l=0.5u
X132 lpopamp_core_0.sliceB_1.bpa_r lpopamp_core_0.sliceB_1.bpa_r a_9150_10800# avdd sg13_hv_pmos ad=1.125p pd=5u as=1.125p ps=5u w=4.5u l=0.5u
X133 a_13250_8400# lpopamp_core_0.sliceB_1.bna avss avss sg13_hv_nmos ad=1.125p pd=5u as=1.125p ps=5u w=4.5u l=3.5u
X134 lpopamp_core_0.sliceA_0.bna_ lpopamp_core_0.sliceA_0.bnb a_9150_700# avss sg13_hv_nmos ad=1.125p pd=5u as=1.125p ps=5u w=4.5u l=0.5u
X135 a_8950_100# lpopamp_core_0.sliceA_0.bnb lpopamp_core_0.sliceA_0.bna_ avss sg13_hv_nmos ad=1.125p pd=5u as=1.125p ps=5u w=4.5u l=0.5u
X136 a_23750_14250# lpopamp_core_0.sliceA_1.zn_m lpopamp_core_0.sliceA_1.yn_p avss sg13_hv_nmos ad=1.125p pd=5u as=1.125p ps=5u w=4.5u l=0.5u
X137 lpopamp_core_0.sliceA_0.enb en avss avss sg13_hv_nmos ad=1.125p pd=5u as=2.25p ps=10u w=4.5u l=1.5u
X138 avdd lpopamp_core_0.sliceB_1.bpa_r a_11150_10200# avdd sg13_hv_pmos ad=1.125p pd=5u as=1.125p ps=5u w=4.5u l=0.5u
X139 a_13250_100# lpopamp_core_0.sliceA_0.bna avss avss sg13_hv_nmos ad=1.125p pd=5u as=1.125p ps=5u w=4.5u l=3.5u
X140 a_12550_14250# lpopamp_core_0.sliceA_1.bna_ a_12450_14250# avss sg13_hv_nmos ad=1.125p pd=5u as=1.125p ps=5u w=4.5u l=0.5u
X141 avdd lpopamp_core_0.sliceB_1.zp_m lpopamp_core_0.sliceB_1.yp_m avdd sg13_hv_pmos ad=1.125p pd=5u as=1.125p ps=5u w=4.5u l=3.5u
X142 lpopamp_core_0.sliceA_1.yn_m lpopamp_core_0.sliceA_1.zn_m a_27550_14250# avss sg13_hv_nmos ad=1.125p pd=5u as=1.125p ps=5u w=4.5u l=0.5u
X143 avdd zp_p out avdd sg13_hv_pmos ad=1.125p pd=5u as=1.125p ps=5u w=4.5u l=0.5u
X144 avss lpopamp_core_0.sliceB_1.zn_m a_17250_8400# avss sg13_hv_nmos ad=1.125p pd=5u as=1.125p ps=5u w=4.5u l=3.5u
X145 lpopamp_core_0.sliceA_0.tihi lpopamp_core_0.sliceA_0.tihi avdd avdd sg13_hv_pmos ad=1.125p pd=5u as=1.125p ps=5u w=4.5u l=9.5u
X146 a_11750_7150# lpopamp_core_0.sliceB_0.bnb lpopamp_core_0.sliceB_0.bna_ avss sg13_hv_nmos ad=1.125p pd=5u as=1.125p ps=5u w=4.5u l=0.5u
X147 lpopamp_core_0.sliceA_1.yp_p lpopamp_core_0.sliceA_1.zp_m lpopamp_core_0.sliceA_1.zp_m avdd sg13_hv_pmos ad=1.125p pd=5u as=1.125p ps=5u w=4.5u l=0.5u
X148 avdd lpopamp_core_0.sliceA_0.zp_m lpopamp_core_0.sliceA_0.yp_m avdd sg13_hv_pmos ad=1.125p pd=5u as=1.125p ps=5u w=4.5u l=3.5u
X149 a_29350_100# zn_p avss avss sg13_hv_nmos ad=1.125p pd=5u as=1.125p ps=5u w=4.5u l=0.5u
X150 lpopamp_core_0.sliceB_1.xn in_p a_13950_8400# avss sg13_hv_nmos ad=1.125p pd=5u as=1.125p ps=5u w=4.5u l=0.5u
X151 lpopamp_core_0.sliceA_1.zn_m lpopamp_core_0.sliceA_1.bpb a_23850_11850# avdd sg13_hv_pmos ad=1.125p pd=5u as=1.125p ps=5u w=4.5u l=0.5u
X152 a_22450_2500# lpopamp_core_0.sliceA_0.bpb lpopamp_core_0.sliceA_0.zn_m avdd sg13_hv_pmos ad=1.125p pd=5u as=1.125p ps=5u w=4.5u l=0.5u
X153 lpopamp_core_0.sliceA_1.yp_m lpopamp_core_0.sliceA_1.zp_m zp_p avdd sg13_hv_pmos ad=1.125p pd=5u as=1.125p ps=5u w=4.5u l=0.5u
X154 lpopamp_core_0.sliceA_1.bna en ib avss sg13_hv_nmos ad=1.125p pd=5u as=1.125p ps=5u w=4.5u l=1.5u
X155 a_16450_7150# lpopamp_core_0.sliceB_0.zn_m avss avss sg13_hv_nmos ad=1.125p pd=5u as=1.125p ps=5u w=4.5u l=3.5u
X156 avdd lpopamp_core_0.sliceB_1.bpa lpopamp_core_0.sliceB_1.bpa avdd sg13_hv_pmos ad=1.125p pd=5u as=1.125p ps=5u w=4.5u l=3.5u
X157 a_28050_8400# lpopamp_core_0.sliceB_1.zn_m lpopamp_core_0.sliceB_1.yn_m avss sg13_hv_nmos ad=1.125p pd=5u as=1.125p ps=5u w=4.5u l=3.5u
X158 ib en lpopamp_core_0.sliceA_0.bna avss sg13_hv_nmos ad=1.125p pd=5u as=1.125p ps=5u w=4.5u l=1.5u
X159 a_8350_8400# lpopamp_core_0.sliceB_1.bna_ a_8250_8400# avss sg13_hv_nmos ad=1.125p pd=5u as=1.125p ps=5u w=4.5u l=0.5u
X160 lpopamp_core_0.sliceA_0.xn in_m a_14350_100# avss sg13_hv_nmos ad=1.125p pd=5u as=1.125p ps=5u w=4.5u l=0.5u
X161 lpopamp_core_0.sliceA_0.xp in_m lpopamp_core_0.sliceA_0.yn_p avdd sg13_hv_pmos ad=1.125p pd=5u as=1.125p ps=5u w=4.5u l=0.5u
X162 out zn_p a_29750_7150# avss sg13_hv_nmos ad=1.125p pd=5u as=1.125p ps=5u w=4.5u l=0.5u
X163 zp_p lpopamp_core_0.sliceA_1.zp_m lpopamp_core_0.sliceA_1.yp_m avdd sg13_hv_pmos ad=1.125p pd=5u as=1.125p ps=5u w=4.5u l=0.5u
X164 a_21150_8400# lpopamp_core_0.sliceB_1.bnb lpopamp_core_0.sliceB_1.zp_m avss sg13_hv_nmos ad=1.125p pd=5u as=1.125p ps=5u w=4.5u l=0.5u
X165 a_23550_700# lpopamp_core_0.sliceA_0.zn_m lpopamp_core_0.sliceA_0.zn_m avss sg13_hv_nmos ad=1.125p pd=5u as=1.125p ps=5u w=4.5u l=0.5u
X166 a_26550_7150# lpopamp_core_0.sliceB_0.bnb zp_p avss sg13_hv_nmos ad=1.125p pd=5u as=1.125p ps=5u w=4.5u l=0.5u
X167 a_10750_14850# lpopamp_core_0.sliceA_1.bnb lpopamp_core_0.sliceA_1.bnb avss sg13_hv_nmos ad=1.125p pd=5u as=1.125p ps=5u w=4.5u l=0.5u
X168 a_8950_12450# lpopamp_core_0.sliceA_1.bpa_r avdd avdd sg13_hv_pmos ad=1.125p pd=5u as=1.125p ps=5u w=4.5u l=0.5u
X169 lpopamp_core_0.sliceA_1.yn_p in_m lpopamp_core_0.sliceA_1.xp avdd sg13_hv_pmos ad=1.125p pd=5u as=1.125p ps=5u w=4.5u l=0.5u
X170 avdd lpopamp_core_0.sliceB_1.bpa a_23850_10200# avdd sg13_hv_pmos ad=1.125p pd=5u as=1.125p ps=5u w=4.5u l=3.5u
X171 zn_p lpopamp_core_0.sliceA_1.zn_m a_25750_14850# avss sg13_hv_nmos ad=1.125p pd=5u as=1.125p ps=5u w=4.5u l=0.5u
X172 zp_p en avdd avdd sg13_hv_pmos ad=1.125p pd=5u as=1.125p ps=5u w=4.5u l=1.5u
X173 lpopamp_core_0.sliceA_1.yp_m in_p a_14550_14850# avss sg13_hv_nmos ad=1.125p pd=5u as=1.125p ps=5u w=4.5u l=0.5u
X174 avdd lpopamp_core_0.sliceB_1.zp_m lpopamp_core_0.sliceB_1.yp_m avdd sg13_hv_pmos ad=1.125p pd=5u as=1.125p ps=5u w=4.5u l=3.5u
X175 lpopamp_core_0.sliceA_0.bpa_r lpopamp_core_0.sliceA_0.bpb lpopamp_core_0.sliceA_0.bpb avdd sg13_hv_pmos ad=1.125p pd=5u as=1.125p ps=5u w=4.5u l=0.5u
X176 a_29750_14850# zn_p avss avss sg13_hv_nmos ad=1.125p pd=5u as=1.125p ps=5u w=4.5u l=0.5u
X177 lpopamp_core_0.sliceB_0.yn_p lpopamp_core_0.sliceB_0.zn_m a_23150_7150# avss sg13_hv_nmos ad=1.125p pd=5u as=1.125p ps=5u w=4.5u l=0.5u
X178 avss lpopamp_core_0.sliceB_1.bna a_15650_7800# avss sg13_hv_nmos ad=1.125p pd=5u as=1.125p ps=5u w=4.5u l=3.5u
X179 lpopamp_core_0.sliceB_1.xp in_p lpopamp_core_0.sliceB_1.yn_m avdd sg13_hv_pmos ad=1.125p pd=5u as=1.125p ps=5u w=4.5u l=0.5u
X180 a_18850_14850# lpopamp_core_0.sliceA_1.zn_m lpopamp_core_0.sliceA_1.yn_m avss sg13_hv_nmos ad=1.125p pd=5u as=1.125p ps=5u w=4.5u l=3.5u
X181 avdd lpopamp_core_0.sliceB_0.bpa lpopamp_core_0.sliceB_0.xp avdd sg13_hv_pmos ad=1.125p pd=5u as=1.125p ps=5u w=4.5u l=3.5u
X182 a_12450_7800# lpopamp_core_0.sliceB_1.bna_ a_12350_7800# avss sg13_hv_nmos ad=1.125p pd=5u as=1.125p ps=5u w=4.5u l=0.5u
X183 lpopamp_core_0.sliceA_0.zn_m lpopamp_core_0.sliceA_0.bpb a_23850_2500# avdd sg13_hv_pmos ad=1.125p pd=5u as=1.125p ps=5u w=4.5u l=0.5u
X184 lpopamp_core_0.sliceA_0.bpa_l lpopamp_core_0.sliceA_0.bpb lpopamp_core_0.sliceA_0.bpb avdd sg13_hv_pmos ad=1.125p pd=5u as=1.125p ps=5u w=4.5u l=0.5u
X185 a_14550_6550# in_m lpopamp_core_0.sliceB_0.xn avss sg13_hv_nmos ad=1.125p pd=5u as=1.125p ps=5u w=4.5u l=0.5u
X186 lpopamp_core_0.sliceA_1.bpb lpopamp_core_0.sliceA_1.bpb lpopamp_core_0.sliceA_1.bpa_l avdd sg13_hv_pmos ad=1.125p pd=5u as=1.125p ps=5u w=4.5u l=0.5u
X187 avss lpopamp_core_0.sliceA_0.bna a_15650_700# avss sg13_hv_nmos ad=1.125p pd=5u as=1.125p ps=5u w=4.5u l=3.5u
X188 lpopamp_core_0.sliceA_0.bpa en avdd avdd sg13_hv_pmos ad=1.125p pd=5u as=1.125p ps=5u w=4.5u l=1.5u
X189 lpopamp_core_0.sliceB_0.bna_ lpopamp_core_0.sliceB_0.bnb a_11150_6550# avss sg13_hv_nmos ad=1.125p pd=5u as=1.125p ps=5u w=4.5u l=0.5u
X190 lpopamp_core_0.sliceB_1.bpa_l lpopamp_core_0.sliceB_1.bpb lpopamp_core_0.sliceB_1.bpb avdd sg13_hv_pmos ad=1.125p pd=5u as=1.125p ps=5u w=4.5u l=0.5u
X191 a_9550_14850# lpopamp_core_0.sliceA_1.bnb lpopamp_core_0.sliceA_1.bnb avss sg13_hv_nmos ad=1.125p pd=5u as=1.125p ps=5u w=4.5u l=0.5u
X192 lpopamp_core_0.sliceB_0.bpa lpopamp_core_0.sliceB_0.bpa avdd avdd sg13_hv_pmos ad=1.125p pd=5u as=1.125p ps=5u w=4.5u l=3.5u
X193 lpopamp_core_0.sliceB_1.yp_p lpopamp_core_0.sliceB_1.zp_m lpopamp_core_0.sliceB_1.zp_m avdd sg13_hv_pmos ad=1.125p pd=5u as=1.125p ps=5u w=4.5u l=0.5u
X194 avss lpopamp_core_0.sliceB_0.enb zn_p avss sg13_hv_nmos ad=2.25p pd=10u as=1.125p ps=5u w=4.5u l=1.5u
X195 out zp_p avdd avdd sg13_hv_pmos ad=1.125p pd=5u as=1.125p ps=5u w=4.5u l=0.5u
X196 lpopamp_core_0.sliceB_1.bpa_r lpopamp_core_0.sliceB_1.bpb lpopamp_core_0.sliceB_1.bpb avdd sg13_hv_pmos ad=1.125p pd=5u as=1.125p ps=5u w=4.5u l=0.5u
X197 lpopamp_core_0.sliceB_0.bpb lpopamp_core_0.sliceB_0.bpb lpopamp_core_0.sliceB_0.bpa_r avdd sg13_hv_pmos ad=1.125p pd=5u as=1.125p ps=5u w=4.5u l=0.5u
X198 a_11550_14250# lpopamp_core_0.sliceA_1.bnb lpopamp_core_0.sliceA_1.bnb avss sg13_hv_nmos ad=1.125p pd=5u as=1.125p ps=5u w=4.5u l=0.5u
X199 zp_p lpopamp_core_0.sliceB_1.zp_m lpopamp_core_0.sliceB_1.yp_m avdd sg13_hv_pmos ad=1.125p pd=5u as=1.125p ps=5u w=4.5u l=0.5u
X200 zn_p lpopamp_core_0.sliceA_1.bnb a_26550_14250# avss sg13_hv_nmos ad=1.125p pd=5u as=1.125p ps=5u w=4.5u l=0.5u
X201 a_25250_6550# lpopamp_core_0.sliceB_0.zn_m avss avss sg13_hv_nmos ad=1.125p pd=5u as=1.125p ps=5u w=4.5u l=3.5u
X202 lpopamp_core_0.sliceB_0.bna_ lpopamp_core_0.sliceB_0.bna_ a_8750_6550# avss sg13_hv_nmos ad=1.125p pd=5u as=1.125p ps=5u w=4.5u l=0.5u
X203 avdd lpopamp_core_0.sliceB_1.zp_m lpopamp_core_0.sliceB_1.yp_m avdd sg13_hv_pmos ad=1.125p pd=5u as=1.125p ps=5u w=4.5u l=3.5u
X204 lpopamp_core_0.sliceB_0.yp_m lpopamp_core_0.sliceB_0.zp_m zp_p avdd sg13_hv_pmos ad=1.125p pd=5u as=1.125p ps=5u w=4.5u l=0.5u
X205 avdd zp_p out avdd sg13_hv_pmos ad=1.125p pd=5u as=1.125p ps=5u w=4.5u l=0.5u
X206 lpopamp_core_0.sliceB_0.zn_m lpopamp_core_0.sliceB_0.bpb a_22450_4150# avdd sg13_hv_pmos ad=1.125p pd=5u as=1.125p ps=5u w=4.5u l=0.5u
X207 a_6650_4150# lpopamp_core_0.sliceB_0.bpa_l a_6550_4150# avdd sg13_hv_pmos ad=1.125p pd=5u as=1.125p ps=5u w=4.5u l=0.5u
X208 lpopamp_core_0.sliceB_1.yn_m lpopamp_core_0.sliceB_1.zn_m a_27150_7800# avss sg13_hv_nmos ad=1.125p pd=5u as=1.125p ps=5u w=4.5u l=0.5u
X209 a_19650_14250# lpopamp_core_0.sliceA_1.bna avss avss sg13_hv_nmos ad=1.125p pd=5u as=1.125p ps=5u w=4.5u l=3.5u
X210 a_29350_6550# zn_p avss avss sg13_hv_nmos ad=1.125p pd=5u as=1.125p ps=5u w=4.5u l=0.5u
X211 avdd lpopamp_core_0.sliceA_1.bpa a_22450_11850# avdd sg13_hv_pmos ad=1.125p pd=5u as=1.125p ps=5u w=4.5u l=3.5u
X212 avss lpopamp_core_0.sliceA_0.bna a_6050_700# avss sg13_hv_nmos ad=1.125p pd=5u as=1.125p ps=5u w=4.5u l=3.5u
X213 zp_p lpopamp_core_0.sliceB_0.zp_m lpopamp_core_0.sliceB_0.yp_m avdd sg13_hv_pmos ad=1.125p pd=5u as=1.125p ps=5u w=4.5u l=0.5u
X214 a_17250_100# lpopamp_core_0.sliceA_0.zn_m lpopamp_core_0.sliceA_0.yn_p avss sg13_hv_nmos ad=1.125p pd=5u as=1.125p ps=5u w=4.5u l=3.5u
X215 a_10150_700# lpopamp_core_0.sliceA_0.bnb lpopamp_core_0.sliceA_0.bna_ avss sg13_hv_nmos ad=1.125p pd=5u as=1.125p ps=5u w=4.5u l=0.5u
X216 lpopamp_core_0.sliceB_0.yn_m lpopamp_core_0.sliceB_0.zn_m a_25950_6550# avss sg13_hv_nmos ad=1.125p pd=5u as=1.125p ps=5u w=4.5u l=0.5u
X217 a_2850_14250# lpopamp_core_0.sliceA_1.bna avss avss sg13_hv_nmos ad=1.125p pd=5u as=1.125p ps=5u w=4.5u l=3.5u
X218 lpopamp_core_0.sliceA_1.yn_p in_m lpopamp_core_0.sliceA_1.xp avdd sg13_hv_pmos ad=1.125p pd=5u as=1.125p ps=5u w=4.5u l=0.5u
X219 a_18050_8400# lpopamp_core_0.sliceB_1.zn_m avss avss sg13_hv_nmos ad=1.125p pd=5u as=1.125p ps=5u w=4.5u l=3.5u
X220 a_9050_10200# lpopamp_core_0.sliceB_1.bpa_r a_8950_10200# avdd sg13_hv_pmos ad=1.125p pd=5u as=1.125p ps=5u w=4.5u l=0.5u
X221 zn_p lpopamp_core_0.sliceA_0.zn_m a_26150_100# avss sg13_hv_nmos ad=1.125p pd=5u as=1.125p ps=5u w=4.5u l=0.5u
X222 lpopamp_core_0.sliceA_0.yp_m lpopamp_core_0.sliceA_0.zp_m avdd avdd sg13_hv_pmos ad=1.125p pd=5u as=1.125p ps=5u w=4.5u l=3.5u
X223 lpopamp_core_0.sliceB_1.xn in_p a_14350_8400# avss sg13_hv_nmos ad=1.125p pd=5u as=1.125p ps=5u w=4.5u l=0.5u
X224 avdd zp_p out avdd sg13_hv_pmos ad=1.125p pd=5u as=1.125p ps=5u w=4.5u l=0.5u
X225 a_20950_14850# lpopamp_core_0.sliceA_1.bnb a_20050_14250# avss sg13_hv_nmos ad=1.125p pd=5u as=1.125p ps=5u w=4.5u l=0.5u
X226 lpopamp_core_0.sliceA_0.bpb lpopamp_core_0.sliceA_0.bpb lpopamp_core_0.sliceA_0.bpa_l avdd sg13_hv_pmos ad=1.125p pd=5u as=1.125p ps=5u w=4.5u l=0.5u
X227 a_11150_8400# lpopamp_core_0.sliceB_1.bnb lpopamp_core_0.sliceB_1.bnb avss sg13_hv_nmos ad=1.125p pd=5u as=1.125p ps=5u w=4.5u l=0.5u
X228 lpopamp_core_0.sliceB_0.yn_m lpopamp_core_0.sliceB_0.zn_m a_16450_7150# avss sg13_hv_nmos ad=1.125p pd=5u as=1.125p ps=5u w=4.5u l=3.5u
X229 lpopamp_core_0.sliceA_1.bpb lpopamp_core_0.sliceA_1.bpb lpopamp_core_0.sliceA_1.bpa_l avdd sg13_hv_pmos ad=1.125p pd=5u as=1.125p ps=5u w=4.5u l=0.5u
X230 avdd lpopamp_core_0.sliceA_1.bpa lpopamp_core_0.sliceA_1.yp_m avdd sg13_hv_pmos ad=1.125p pd=5u as=1.125p ps=5u w=4.5u l=3.5u
X231 a_23850_10200# lpopamp_core_0.sliceB_1.bpa avdd avdd sg13_hv_pmos ad=1.125p pd=5u as=1.125p ps=5u w=4.5u l=3.5u
X232 lpopamp_core_0.sliceA_0.zp_m lpopamp_core_0.sliceA_0.zp_m lpopamp_core_0.sliceA_0.yp_p avdd sg13_hv_pmos ad=1.125p pd=5u as=1.125p ps=5u w=4.5u l=0.5u
X233 zn_p lpopamp_core_0.sliceB_1.bpb zp_p avdd sg13_hv_pmos ad=1.125p pd=5u as=1.125p ps=5u w=4.5u l=0.5u
X234 a_28750_14850# zn_p out avss sg13_hv_nmos ad=1.125p pd=5u as=1.125p ps=5u w=4.5u l=0.5u
X235 a_7650_100# lpopamp_core_0.sliceA_0.bna lpopamp_core_0.sliceA_0.bpb avss sg13_hv_nmos ad=1.125p pd=5u as=1.125p ps=5u w=4.5u l=3.5u
X236 a_8750_8400# lpopamp_core_0.sliceB_1.bna_ a_8650_8400# avss sg13_hv_nmos ad=1.125p pd=5u as=1.125p ps=5u w=4.5u l=0.5u
X237 a_11350_100# lpopamp_core_0.sliceA_0.bnb lpopamp_core_0.sliceA_0.bna_ avss sg13_hv_nmos ad=1.125p pd=5u as=1.125p ps=5u w=4.5u l=0.5u
X238 a_20050_100# lpopamp_core_0.sliceA_0.bnb a_20350_700# avss sg13_hv_nmos ad=1.125p pd=5u as=1.125p ps=5u w=4.5u l=0.5u
X239 a_27550_700# lpopamp_core_0.sliceA_0.zn_m zn_p avss sg13_hv_nmos ad=1.125p pd=5u as=1.125p ps=5u w=4.5u l=0.5u
X240 a_26950_7150# lpopamp_core_0.sliceB_0.bnb zp_p avss sg13_hv_nmos ad=1.125p pd=5u as=1.125p ps=5u w=4.5u l=0.5u
X241 a_6750_11850# lpopamp_core_0.sliceA_1.bpa_l a_6650_11850# avdd sg13_hv_pmos ad=1.125p pd=5u as=1.125p ps=5u w=4.5u l=0.5u
X242 avss zn_p a_29150_8400# avss sg13_hv_nmos ad=1.125p pd=5u as=1.125p ps=5u w=4.5u l=0.5u
X243 lpopamp_core_0.sliceB_1.enb en avss avss sg13_hv_nmos ad=1.125p pd=5u as=2.25p ps=10u w=4.5u l=1.5u
X244 lpopamp_core_0.sliceA_0.bpa_r lpopamp_core_0.sliceA_0.bpb lpopamp_core_0.sliceA_0.bpb avdd sg13_hv_pmos ad=1.125p pd=5u as=1.125p ps=5u w=4.5u l=0.5u
X245 lpopamp_core_0.sliceB_0.yn_p lpopamp_core_0.sliceB_0.zn_m a_23550_7150# avss sg13_hv_nmos ad=1.125p pd=5u as=1.125p ps=5u w=4.5u l=0.5u
X246 lpopamp_core_0.sliceB_1.bpa_l lpopamp_core_0.sliceB_1.bpb lpopamp_core_0.sliceB_1.bpb avdd sg13_hv_pmos ad=1.125p pd=5u as=1.125p ps=5u w=4.5u l=0.5u
X247 lpopamp_core_0.sliceA_0.yn_m in_p lpopamp_core_0.sliceA_0.xp avdd sg13_hv_pmos ad=1.125p pd=5u as=1.125p ps=5u w=4.5u l=0.5u
X248 a_8550_14850# lpopamp_core_0.sliceA_1.bna_ a_8450_14850# avss sg13_hv_nmos ad=1.125p pd=5u as=1.125p ps=5u w=4.5u l=0.5u
X249 a_20350_7150# lpopamp_core_0.sliceB_0.bnb lpopamp_core_0.sliceB_0.zp_m avss sg13_hv_nmos ad=1.125p pd=5u as=1.125p ps=5u w=4.5u l=0.5u
X250 avss lpopamp_core_0.sliceB_1.bna_ a_12750_7800# avss sg13_hv_nmos ad=1.125p pd=5u as=1.125p ps=5u w=4.5u l=0.5u
X251 avss lpopamp_core_0.sliceA_1.bna a_21650_14250# avss sg13_hv_nmos ad=1.125p pd=5u as=1.125p ps=5u w=4.5u l=3.5u
X252 a_10550_14250# lpopamp_core_0.sliceA_1.bnb lpopamp_core_0.sliceA_1.bna_ avss sg13_hv_nmos ad=1.125p pd=5u as=1.125p ps=5u w=4.5u l=0.5u
X253 lpopamp_core_0.sliceB_1.zn_m lpopamp_core_0.sliceB_1.bpb a_23850_10200# avdd sg13_hv_pmos ad=1.125p pd=5u as=1.125p ps=5u w=4.5u l=0.5u
X254 a_8650_700# lpopamp_core_0.sliceA_0.bna_ a_8550_700# avss sg13_hv_nmos ad=1.125p pd=5u as=1.125p ps=5u w=4.5u l=0.5u
X255 a_20050_100# lpopamp_core_0.sliceA_0.bna a_19650_700# avss sg13_hv_nmos ad=1.125p pd=5u as=1.125p ps=5u w=4.5u l=3.5u
X256 a_14950_6550# in_m lpopamp_core_0.sliceB_0.xn avss sg13_hv_nmos ad=1.125p pd=5u as=1.125p ps=5u w=4.5u l=0.5u
X257 lpopamp_core_0.sliceA_1.xn in_m a_14350_14250# avss sg13_hv_nmos ad=1.125p pd=5u as=1.125p ps=5u w=4.5u l=0.5u
X258 a_12650_700# lpopamp_core_0.sliceA_0.bna_ a_12550_700# avss sg13_hv_nmos ad=1.125p pd=5u as=1.125p ps=5u w=4.5u l=0.5u
X259 a_29550_14250# zn_p out avss sg13_hv_nmos ad=1.125p pd=5u as=1.125p ps=5u w=4.5u l=0.5u
X260 lpopamp_core_0.sliceB_1.xp in_p lpopamp_core_0.sliceB_1.yn_m avdd sg13_hv_pmos ad=1.125p pd=5u as=1.125p ps=5u w=4.5u l=0.5u
X261 lpopamp_core_0.sliceA_0.bpa lpopamp_core_0.sliceA_0.bpa avdd avdd sg13_hv_pmos ad=1.125p pd=5u as=1.125p ps=5u w=4.5u l=3.5u
X262 lpopamp_core_0.sliceB_0.bna_ lpopamp_core_0.sliceB_0.bnb a_11550_6550# avss sg13_hv_nmos ad=1.125p pd=5u as=1.125p ps=5u w=4.5u l=0.5u
X263 out zp_p a_28650_3100# avdd sg13_hv_pmos ad=1.125p pd=5u as=1.125p ps=5u w=4.5u l=0.5u
X264 a_19650_6550# lpopamp_core_0.sliceB_0.bna avss avss sg13_hv_nmos ad=1.125p pd=5u as=1.125p ps=5u w=4.5u l=3.5u
X265 out zn_p a_28950_700# avss sg13_hv_nmos ad=1.125p pd=5u as=1.125p ps=5u w=4.5u l=0.5u
X266 a_28750_100# zn_p out avss sg13_hv_nmos ad=1.125p pd=5u as=1.125p ps=5u w=4.5u l=0.5u
X267 a_22450_11850# lpopamp_core_0.sliceA_1.bpa avdd avdd sg13_hv_pmos ad=1.125p pd=5u as=1.125p ps=5u w=4.5u l=3.5u
X268 lpopamp_core_0.sliceB_0.yn_m in_p lpopamp_core_0.sliceB_0.xp avdd sg13_hv_pmos ad=1.125p pd=5u as=1.125p ps=5u w=4.5u l=0.5u
X269 lpopamp_core_0.sliceA_0.yp_m lpopamp_core_0.sliceA_0.zp_m zp_p avdd sg13_hv_pmos ad=1.125p pd=5u as=1.125p ps=5u w=4.5u l=0.5u
X270 lpopamp_core_0.sliceA_0.bpb lpopamp_core_0.sliceA_0.bpb lpopamp_core_0.sliceA_0.bpa_r avdd sg13_hv_pmos ad=1.125p pd=5u as=1.125p ps=5u w=4.5u l=0.5u
X271 out zp_p avdd avdd sg13_hv_pmos ad=1.125p pd=5u as=1.125p ps=5u w=4.5u l=0.5u
X272 lpopamp_core_0.sliceA_1.yp_m lpopamp_core_0.sliceA_1.zp_m zp_p avdd sg13_hv_pmos ad=1.125p pd=5u as=1.125p ps=5u w=4.5u l=0.5u
X273 lpopamp_core_0.sliceA_1.yp_p lpopamp_core_0.sliceA_1.zp_m lpopamp_core_0.sliceA_1.zp_m avdd sg13_hv_pmos ad=1.125p pd=5u as=1.125p ps=5u w=4.5u l=0.5u
X274 a_22450_2500# lpopamp_core_0.sliceA_0.bpa avdd avdd sg13_hv_pmos ad=1.125p pd=5u as=1.125p ps=5u w=4.5u l=3.5u
X275 lpopamp_core_0.sliceB_1.yn_m lpopamp_core_0.sliceB_1.zn_m a_27550_7800# avss sg13_hv_nmos ad=1.125p pd=5u as=1.125p ps=5u w=4.5u l=0.5u
X276 lpopamp_core_0.sliceB_1.bpa_l lpopamp_core_0.sliceB_1.bpb lpopamp_core_0.sliceB_1.bpb avdd sg13_hv_pmos ad=1.125p pd=5u as=1.125p ps=5u w=4.5u l=0.5u
X277 a_9350_14250# lpopamp_core_0.sliceA_1.bnb lpopamp_core_0.sliceA_1.bna_ avss sg13_hv_nmos ad=1.125p pd=5u as=1.125p ps=5u w=4.5u l=0.5u
X278 lpopamp_core_0.sliceA_0.yn_p in_m lpopamp_core_0.sliceA_0.xp avdd sg13_hv_pmos ad=1.125p pd=5u as=1.125p ps=5u w=4.5u l=0.5u
X279 lpopamp_core_0.sliceB_0.bpa_l lpopamp_core_0.sliceB_0.bpb lpopamp_core_0.sliceB_0.bpb avdd sg13_hv_pmos ad=1.125p pd=5u as=1.125p ps=5u w=4.5u l=0.5u
X280 a_29750_6550# zn_p avss avss sg13_hv_nmos ad=1.125p pd=5u as=1.125p ps=5u w=4.5u l=0.5u
X281 a_8250_7800# lpopamp_core_0.sliceB_1.bna_ a_8150_7800# avss sg13_hv_nmos ad=1.125p pd=5u as=1.125p ps=5u w=4.5u l=0.5u
X282 lpopamp_core_0.sliceA_0.bnb lpopamp_core_0.sliceA_0.bnb a_9750_100# avss sg13_hv_nmos ad=1.125p pd=5u as=1.125p ps=5u w=4.5u l=0.5u
X283 avss zn_p a_29950_14850# avss sg13_hv_nmos ad=1.125p pd=5u as=1.125p ps=5u w=4.5u l=0.5u
X284 lpopamp_core_0.sliceA_1.bpa_r lpopamp_core_0.sliceA_1.bpb lpopamp_core_0.sliceA_1.bpb avdd sg13_hv_pmos ad=1.125p pd=5u as=1.125p ps=5u w=4.5u l=0.5u
X285 zp_p lpopamp_core_0.sliceB_0.bpb zn_p avdd sg13_hv_pmos ad=1.125p pd=5u as=1.125p ps=5u w=4.5u l=0.5u
X286 lpopamp_core_0.sliceB_0.yp_p lpopamp_core_0.sliceB_0.zp_m lpopamp_core_0.sliceB_0.zp_m avdd sg13_hv_pmos ad=1.125p pd=5u as=1.125p ps=5u w=4.5u l=0.5u
X287 zp_p lpopamp_core_0.sliceA_1.bpb zn_p avdd sg13_hv_pmos ad=1.125p pd=5u as=1.125p ps=5u w=4.5u l=0.5u
X288 a_14150_700# in_m lpopamp_core_0.sliceA_0.xn avss sg13_hv_nmos ad=1.125p pd=5u as=1.125p ps=5u w=4.5u l=0.5u
X289 lpopamp_core_0.sliceA_0.yp_p in_m a_13750_100# avss sg13_hv_nmos ad=1.125p pd=5u as=1.125p ps=5u w=4.5u l=0.5u
X290 zp_p lpopamp_core_0.sliceB_0.bnb a_26350_6550# avss sg13_hv_nmos ad=1.125p pd=5u as=1.125p ps=5u w=4.5u l=0.5u
X291 lpopamp_core_0.sliceB_1.zp_m lpopamp_core_0.sliceB_1.bnb a_20950_7800# avss sg13_hv_nmos ad=1.125p pd=5u as=1.125p ps=5u w=4.5u l=0.5u
X292 lpopamp_core_0.sliceA_1.zn_m lpopamp_core_0.sliceA_1.zn_m a_23750_14850# avss sg13_hv_nmos ad=1.125p pd=5u as=1.125p ps=5u w=4.5u l=0.5u
X293 lpopamp_core_0.sliceA_1.bpb lpopamp_core_0.sliceA_1.bpb lpopamp_core_0.sliceA_1.bpa_l avdd sg13_hv_pmos ad=1.125p pd=5u as=1.125p ps=5u w=4.5u l=0.5u
X294 a_29850_11850# zp_p out avdd sg13_hv_pmos ad=1.125p pd=5u as=1.125p ps=5u w=4.5u l=0.5u
X295 lpopamp_core_0.sliceB_1.zn_m lpopamp_core_0.sliceB_1.bpb a_22450_10200# avdd sg13_hv_pmos ad=1.125p pd=5u as=1.125p ps=5u w=4.5u l=0.5u
X296 a_23850_4150# lpopamp_core_0.sliceB_0.bpb lpopamp_core_0.sliceB_0.zn_m avdd sg13_hv_pmos ad=1.125p pd=5u as=1.125p ps=5u w=4.5u l=0.5u
X297 lpopamp_core_0.sliceB_1.bnb lpopamp_core_0.sliceB_1.bpa avdd avdd sg13_hv_pmos ad=1.125p pd=5u as=1.125p ps=5u w=4.5u l=3.5u
X298 a_22950_700# lpopamp_core_0.sliceA_0.zn_m lpopamp_core_0.sliceA_0.yn_p avss sg13_hv_nmos ad=1.125p pd=5u as=1.125p ps=5u w=4.5u l=0.5u
X299 lpopamp_core_0.sliceA_0.bpb lpopamp_core_0.sliceA_0.bpb lpopamp_core_0.sliceA_0.bpa_r avdd sg13_hv_pmos ad=1.125p pd=5u as=1.125p ps=5u w=4.5u l=0.5u
X300 lpopamp_core_0.sliceB_0.bpb lpopamp_core_0.sliceB_0.bpb lpopamp_core_0.sliceB_0.bpa_l avdd sg13_hv_pmos ad=1.125p pd=5u as=1.125p ps=5u w=4.5u l=0.5u
X301 a_12650_14850# lpopamp_core_0.sliceA_1.bna_ a_12550_14850# avss sg13_hv_nmos ad=1.125p pd=5u as=1.125p ps=5u w=4.5u l=0.5u
X302 lpopamp_core_0.sliceA_1.xp in_p lpopamp_core_0.sliceA_1.yn_m avdd sg13_hv_pmos ad=1.125p pd=5u as=1.125p ps=5u w=4.5u l=0.5u
X303 a_23150_6550# lpopamp_core_0.sliceB_0.zn_m lpopamp_core_0.sliceB_0.zn_m avss sg13_hv_nmos ad=1.125p pd=5u as=1.125p ps=5u w=4.5u l=0.5u
X304 a_28050_14850# lpopamp_core_0.sliceA_1.zn_m lpopamp_core_0.sliceA_1.yn_m avss sg13_hv_nmos ad=1.125p pd=5u as=1.125p ps=5u w=4.5u l=3.5u
X305 lpopamp_core_0.sliceA_1.yn_p lpopamp_core_0.sliceA_1.zn_m a_16450_14850# avss sg13_hv_nmos ad=1.125p pd=5u as=1.125p ps=5u w=4.5u l=3.5u
X306 a_23150_100# lpopamp_core_0.sliceA_0.zn_m lpopamp_core_0.sliceA_0.zn_m avss sg13_hv_nmos ad=1.125p pd=5u as=1.125p ps=5u w=4.5u l=0.5u
X307 lpopamp_core_0.sliceB_1.xn in_m a_14750_8400# avss sg13_hv_nmos ad=1.125p pd=5u as=1.125p ps=5u w=4.5u l=0.5u
X308 lpopamp_core_0.sliceA_0.bpb lpopamp_core_0.sliceA_0.bpb lpopamp_core_0.sliceA_0.bpa_l avdd sg13_hv_pmos ad=1.125p pd=5u as=1.125p ps=5u w=4.5u l=0.5u
X309 a_11550_8400# lpopamp_core_0.sliceB_1.bnb lpopamp_core_0.sliceB_1.bnb avss sg13_hv_nmos ad=1.125p pd=5u as=1.125p ps=5u w=4.5u l=0.5u
X310 a_17250_7150# lpopamp_core_0.sliceB_0.zn_m lpopamp_core_0.sliceB_0.yn_m avss sg13_hv_nmos ad=1.125p pd=5u as=1.125p ps=5u w=4.5u l=3.5u
X311 lpopamp_core_0.sliceA_1.bpa lpopamp_core_0.sliceA_1.bpa avdd avdd sg13_hv_pmos ad=1.125p pd=5u as=1.125p ps=5u w=4.5u l=3.5u
X312 avdd en lpopamp_core_0.sliceB_1.enb avdd sg13_hv_pmos ad=1.125p pd=5u as=1.125p ps=5u w=4.5u l=1.5u
X313 lpopamp_core_0.sliceA_1.bpa_r lpopamp_core_0.sliceA_1.bpb lpopamp_core_0.sliceA_1.bpb avdd sg13_hv_pmos ad=1.125p pd=5u as=1.125p ps=5u w=4.5u l=0.5u
X314 a_10350_7150# lpopamp_core_0.sliceB_0.bnb lpopamp_core_0.sliceB_0.bnb avss sg13_hv_nmos ad=1.125p pd=5u as=1.125p ps=5u w=4.5u l=0.5u
X315 a_15650_100# lpopamp_core_0.sliceA_0.bna lpopamp_core_0.sliceA_0.xn avss sg13_hv_nmos ad=1.125p pd=5u as=1.125p ps=5u w=4.5u l=3.5u
X316 a_20750_14250# lpopamp_core_0.sliceA_1.bnb lpopamp_core_0.sliceA_1.zp_m avss sg13_hv_nmos ad=1.125p pd=5u as=1.125p ps=5u w=4.5u l=0.5u
X317 lpopamp_core_0.sliceB_1.bnb lpopamp_core_0.sliceB_1.bpa avdd avdd sg13_hv_pmos ad=1.125p pd=5u as=1.125p ps=5u w=4.5u l=3.5u
X318 lpopamp_core_0.sliceB_1.yp_m lpopamp_core_0.sliceB_1.zp_m zp_p avdd sg13_hv_pmos ad=1.125p pd=5u as=1.125p ps=5u w=4.5u l=0.5u
X319 avss zn_p a_29550_8400# avss sg13_hv_nmos ad=1.125p pd=5u as=1.125p ps=5u w=4.5u l=0.5u
X320 a_28550_14250# zn_p avss avss sg13_hv_nmos ad=1.125p pd=5u as=1.125p ps=5u w=4.5u l=0.5u
X321 a_2850_8400# lpopamp_core_0.sliceB_1.bna avss avss sg13_hv_nmos ad=1.125p pd=5u as=1.125p ps=5u w=4.5u l=3.5u
X322 avss lpopamp_core_0.sliceA_1.zn_m a_17250_14250# avss sg13_hv_nmos ad=1.125p pd=5u as=1.125p ps=5u w=4.5u l=3.5u
X323 lpopamp_core_0.sliceA_0.yn_m in_p lpopamp_core_0.sliceA_0.xp avdd sg13_hv_pmos ad=1.125p pd=5u as=1.125p ps=5u w=4.5u l=0.5u
X324 a_26350_8400# lpopamp_core_0.sliceB_1.bnb zn_p avss sg13_hv_nmos ad=1.125p pd=5u as=1.125p ps=5u w=4.5u l=0.5u
X325 a_20750_7150# lpopamp_core_0.sliceB_0.bnb lpopamp_core_0.sliceB_0.zp_m avss sg13_hv_nmos ad=1.125p pd=5u as=1.125p ps=5u w=4.5u l=0.5u
X326 lpopamp_core_0.sliceA_1.zp_m lpopamp_core_0.sliceA_1.zp_m lpopamp_core_0.sliceA_1.yp_p avdd sg13_hv_pmos ad=1.125p pd=5u as=1.125p ps=5u w=4.5u l=0.5u
X327 lpopamp_core_0.sliceB_1.zn_m lpopamp_core_0.sliceB_1.zn_m a_22950_8400# avss sg13_hv_nmos ad=1.125p pd=5u as=1.125p ps=5u w=4.5u l=0.5u
X328 lpopamp_core_0.sliceB_0.zp_m lpopamp_core_0.sliceB_0.zp_m lpopamp_core_0.sliceB_0.yp_p avdd sg13_hv_pmos ad=1.125p pd=5u as=1.125p ps=5u w=4.5u l=0.5u
X329 avdd lpopamp_core_0.sliceA_1.zp_m lpopamp_core_0.sliceA_1.yp_m avdd sg13_hv_pmos ad=1.125p pd=5u as=1.125p ps=5u w=4.5u l=3.5u
X330 lpopamp_core_0.sliceA_0.bnb lpopamp_core_0.sliceA_0.bpa avdd avdd sg13_hv_pmos ad=1.125p pd=5u as=1.125p ps=5u w=4.5u l=3.5u
X331 lpopamp_core_0.sliceA_1.xp in_p lpopamp_core_0.sliceA_1.yn_m avdd sg13_hv_pmos ad=1.125p pd=5u as=1.125p ps=5u w=4.5u l=0.5u
X332 lpopamp_core_0.sliceB_0.xp in_p lpopamp_core_0.sliceB_0.yn_m avdd sg13_hv_pmos ad=1.125p pd=5u as=1.125p ps=5u w=4.5u l=0.5u
X333 lpopamp_core_0.sliceB_0.bnb lpopamp_core_0.sliceB_0.bnb a_8950_7150# avss sg13_hv_nmos ad=1.125p pd=5u as=1.125p ps=5u w=4.5u l=0.5u
X334 lpopamp_core_0.sliceB_1.bpa_l lpopamp_core_0.sliceB_1.bpb lpopamp_core_0.sliceB_1.bpb avdd sg13_hv_pmos ad=1.125p pd=5u as=1.125p ps=5u w=4.5u l=0.5u
X335 a_8350_14250# lpopamp_core_0.sliceA_1.bna_ a_8250_14250# avss sg13_hv_nmos ad=1.125p pd=5u as=1.125p ps=5u w=4.5u l=0.5u
X336 avdd lpopamp_core_0.sliceB_0.zp_m lpopamp_core_0.sliceB_0.yp_m avdd sg13_hv_pmos ad=1.125p pd=5u as=1.125p ps=5u w=4.5u l=3.5u
X337 a_20050_6550# lpopamp_core_0.sliceB_0.bna a_19650_6550# avss sg13_hv_nmos ad=1.125p pd=5u as=1.125p ps=5u w=4.5u l=3.5u
X338 a_14350_7800# in_p lpopamp_core_0.sliceB_1.yp_m avss sg13_hv_nmos ad=1.125p pd=5u as=1.125p ps=5u w=4.5u l=0.5u
X339 zn_p lpopamp_core_0.sliceA_0.bpb zp_p avdd sg13_hv_pmos ad=1.125p pd=5u as=1.125p ps=5u w=4.5u l=0.5u
X340 lpopamp_core_0.sliceB_0.bpa_r lpopamp_core_0.sliceB_0.bpb lpopamp_core_0.sliceB_0.bpb avdd sg13_hv_pmos ad=1.125p pd=5u as=1.125p ps=5u w=4.5u l=0.5u
X341 lpopamp_core_0.sliceA_1.yp_m lpopamp_core_0.sliceA_1.zp_m avdd avdd sg13_hv_pmos ad=1.125p pd=5u as=1.125p ps=5u w=4.5u l=3.5u
X342 lpopamp_core_0.sliceA_0.bpb lpopamp_core_0.sliceA_0.bpb lpopamp_core_0.sliceA_0.bpa_r avdd sg13_hv_pmos ad=1.125p pd=5u as=1.125p ps=5u w=4.5u l=0.5u
X343 lpopamp_core_0.sliceB_1.bnb lpopamp_core_0.sliceB_1.bnb a_10950_7800# avss sg13_hv_nmos ad=1.125p pd=5u as=1.125p ps=5u w=4.5u l=0.5u
X344 lpopamp_core_0.sliceA_1.yp_p lpopamp_core_0.sliceA_1.zp_m avdd avdd sg13_hv_pmos ad=1.125p pd=5u as=1.125p ps=5u w=4.5u l=3.5u
X345 avdd zp_p out avdd sg13_hv_pmos ad=1.125p pd=5u as=1.125p ps=5u w=4.5u l=0.5u
X346 lpopamp_core_0.sliceB_1.zp_m lpopamp_core_0.sliceB_1.zp_m lpopamp_core_0.sliceB_1.yp_p avdd sg13_hv_pmos ad=1.125p pd=5u as=1.125p ps=5u w=4.5u l=0.5u
X347 lpopamp_core_0.sliceB_1.bpb lpopamp_core_0.sliceB_1.bpb lpopamp_core_0.sliceB_1.bpa_r avdd sg13_hv_pmos ad=1.125p pd=5u as=1.125p ps=5u w=4.5u l=0.5u
X348 lpopamp_core_0.sliceA_0.zn_m lpopamp_core_0.sliceA_0.bpb a_22450_2500# avdd sg13_hv_pmos ad=1.125p pd=5u as=1.125p ps=5u w=4.5u l=0.5u
X349 zn_p lpopamp_core_0.sliceB_1.enb avss avss sg13_hv_nmos ad=1.125p pd=5u as=1.125p ps=5u w=4.5u l=1.5u
X350 lpopamp_core_0.sliceA_1.bna_ lpopamp_core_0.sliceA_1.bnb a_11550_14850# avss sg13_hv_nmos ad=1.125p pd=5u as=1.125p ps=5u w=4.5u l=0.5u
X351 lpopamp_core_0.sliceA_1.bpa_r lpopamp_core_0.sliceA_1.bpb lpopamp_core_0.sliceA_1.bpb avdd sg13_hv_pmos ad=1.125p pd=5u as=1.125p ps=5u w=4.5u l=0.5u
X352 lpopamp_core_0.sliceB_1.yp_m lpopamp_core_0.sliceB_1.zp_m zp_p avdd sg13_hv_pmos ad=1.125p pd=5u as=1.125p ps=5u w=4.5u l=0.5u
X353 a_26750_14850# lpopamp_core_0.sliceA_1.bnb zn_p avss sg13_hv_nmos ad=1.125p pd=5u as=1.125p ps=5u w=4.5u l=0.5u
X354 out zp_p avdd avdd sg13_hv_pmos ad=1.125p pd=5u as=1.125p ps=5u w=4.5u l=0.5u
X355 lpopamp_core_0.sliceB_0.bpa_l lpopamp_core_0.sliceB_0.bpb lpopamp_core_0.sliceB_0.bpb avdd sg13_hv_pmos ad=1.125p pd=5u as=1.125p ps=5u w=4.5u l=0.5u
X356 lpopamp_core_0.sliceB_1.yn_p in_m lpopamp_core_0.sliceB_1.xp avdd sg13_hv_pmos ad=1.125p pd=5u as=1.125p ps=5u w=4.5u l=0.5u
X357 a_8650_7800# lpopamp_core_0.sliceB_1.bna_ a_8550_7800# avss sg13_hv_nmos ad=1.125p pd=5u as=1.125p ps=5u w=4.5u l=0.5u
X358 zp_p lpopamp_core_0.sliceB_0.zp_m lpopamp_core_0.sliceB_0.yp_m avdd sg13_hv_pmos ad=1.125p pd=5u as=1.125p ps=5u w=4.5u l=0.5u
X359 lpopamp_core_0.sliceB_1.bpa lpopamp_core_0.sliceB_1.bna a_5250_7800# avss sg13_hv_nmos ad=1.125p pd=5u as=1.125p ps=5u w=4.5u l=3.5u
X360 lpopamp_core_0.sliceA_0.bnb lpopamp_core_0.sliceA_0.bnb a_10950_700# avss sg13_hv_nmos ad=1.125p pd=5u as=1.125p ps=5u w=4.5u l=0.5u
X361 lpopamp_core_0.sliceA_0.yn_m lpopamp_core_0.sliceA_0.zn_m a_18050_700# avss sg13_hv_nmos ad=1.125p pd=5u as=1.125p ps=5u w=4.5u l=3.5u
X362 a_10750_100# lpopamp_core_0.sliceA_0.bnb lpopamp_core_0.sliceA_0.bnb avss sg13_hv_nmos ad=1.125p pd=5u as=1.125p ps=5u w=4.5u l=0.5u
X363 zp_p lpopamp_core_0.sliceB_0.bnb a_26750_6550# avss sg13_hv_nmos ad=1.125p pd=5u as=1.125p ps=5u w=4.5u l=0.5u
X364 avdd lpopamp_core_0.sliceB_0.zp_m lpopamp_core_0.sliceB_0.yp_m avdd sg13_hv_pmos ad=1.125p pd=5u as=1.125p ps=5u w=4.5u l=3.5u
X365 avdd en lpopamp_core_0.sliceA_1.bpa avdd sg13_hv_pmos ad=1.125p pd=5u as=1.125p ps=5u w=4.5u l=1.5u
X366 a_8550_4150# lpopamp_core_0.sliceB_0.bpa_l lpopamp_core_0.sliceB_0.bpa_l avdd sg13_hv_pmos ad=1.125p pd=5u as=1.125p ps=5u w=4.5u l=0.5u
X367 a_29150_7800# zn_p out avss sg13_hv_nmos ad=1.125p pd=5u as=1.125p ps=5u w=4.5u l=0.5u
X368 a_26950_700# lpopamp_core_0.sliceA_0.bnb zp_p avss sg13_hv_nmos ad=1.125p pd=5u as=1.125p ps=5u w=4.5u l=0.5u
X369 lpopamp_core_0.sliceA_0.bpb lpopamp_core_0.sliceA_0.bpb lpopamp_core_0.sliceA_0.bpa_r avdd sg13_hv_pmos ad=1.125p pd=5u as=1.125p ps=5u w=4.5u l=0.5u
X370 a_23550_6550# lpopamp_core_0.sliceB_0.zn_m lpopamp_core_0.sliceB_0.zn_m avss sg13_hv_nmos ad=1.125p pd=5u as=1.125p ps=5u w=4.5u l=0.5u
X371 a_8650_11850# lpopamp_core_0.sliceA_1.bpa_l a_8550_11850# avdd sg13_hv_pmos ad=1.125p pd=5u as=1.125p ps=5u w=4.5u l=0.5u
X372 lpopamp_core_0.sliceA_0.xp in_p lpopamp_core_0.sliceA_0.yn_m avdd sg13_hv_pmos ad=1.125p pd=5u as=1.125p ps=5u w=4.5u l=0.5u
X373 lpopamp_core_0.sliceB_0.zp_m lpopamp_core_0.sliceB_0.zp_m lpopamp_core_0.sliceB_0.yp_p avdd sg13_hv_pmos ad=1.125p pd=5u as=1.125p ps=5u w=4.5u l=0.5u
X374 a_6850_14850# lpopamp_core_0.sliceA_1.bna avss avss sg13_hv_nmos ad=1.125p pd=5u as=1.125p ps=5u w=4.5u l=3.5u
X375 a_27150_100# lpopamp_core_0.sliceA_0.zn_m zn_p avss sg13_hv_nmos ad=1.125p pd=5u as=1.125p ps=5u w=4.5u l=0.5u
X376 lpopamp_core_0.sliceB_0.zp_m lpopamp_core_0.sliceB_0.bnb a_20150_6550# avss sg13_hv_nmos ad=1.125p pd=5u as=1.125p ps=5u w=4.5u l=0.5u
X377 a_29050_4150# zp_p out avdd sg13_hv_pmos ad=1.125p pd=5u as=1.125p ps=5u w=4.5u l=0.5u
X378 avss lpopamp_core_0.sliceB_0.bna a_4050_6550# avss sg13_hv_nmos ad=1.125p pd=5u as=1.125p ps=5u w=4.5u l=3.5u
X379 a_9150_10800# lpopamp_core_0.sliceB_1.bpa_r a_9050_10800# avdd sg13_hv_pmos ad=1.125p pd=5u as=1.125p ps=5u w=4.5u l=0.5u
X380 a_11950_8400# lpopamp_core_0.sliceB_1.bnb lpopamp_core_0.sliceB_1.bnb avss sg13_hv_nmos ad=1.125p pd=5u as=1.125p ps=5u w=4.5u l=0.5u
X381 lpopamp_core_0.sliceA_1.yn_p lpopamp_core_0.sliceA_1.zn_m a_23550_14250# avss sg13_hv_nmos ad=1.125p pd=5u as=1.125p ps=5u w=4.5u l=0.5u
X382 a_11150_10200# lpopamp_core_0.sliceB_1.bpa_r a_11050_10200# avdd sg13_hv_pmos ad=1.125p pd=5u as=1.125p ps=5u w=4.5u l=0.5u
X383 a_12450_14250# lpopamp_core_0.sliceA_1.bna_ a_12350_14250# avss sg13_hv_nmos ad=1.125p pd=5u as=1.125p ps=5u w=4.5u l=0.5u
X384 lpopamp_core_0.sliceB_1.yp_m lpopamp_core_0.sliceB_1.zp_m zp_p avdd sg13_hv_pmos ad=1.125p pd=5u as=1.125p ps=5u w=4.5u l=0.5u
X385 a_27550_14250# lpopamp_core_0.sliceA_1.zn_m zn_p avss sg13_hv_nmos ad=1.125p pd=5u as=1.125p ps=5u w=4.5u l=0.5u
X386 avdd zp_p out avdd sg13_hv_pmos ad=1.125p pd=5u as=1.125p ps=5u w=4.5u l=0.5u
X387 a_8250_100# lpopamp_core_0.sliceA_0.bna_ a_8150_100# avss sg13_hv_nmos ad=1.125p pd=5u as=1.125p ps=5u w=4.5u l=0.5u
X388 a_12250_100# lpopamp_core_0.sliceA_0.bna_ a_12150_100# avss sg13_hv_nmos ad=1.125p pd=5u as=1.125p ps=5u w=4.5u l=0.5u
X389 a_19650_100# lpopamp_core_0.sliceA_0.bna avss avss sg13_hv_nmos ad=1.125p pd=5u as=1.125p ps=5u w=4.5u l=3.5u
X390 a_10750_7150# lpopamp_core_0.sliceB_0.bnb lpopamp_core_0.sliceB_0.bnb avss sg13_hv_nmos ad=1.125p pd=5u as=1.125p ps=5u w=4.5u l=0.5u
X391 lpopamp_core_0.sliceA_1.zp_m lpopamp_core_0.sliceA_1.zp_m lpopamp_core_0.sliceA_1.yp_p avdd sg13_hv_pmos ad=1.125p pd=5u as=1.125p ps=5u w=4.5u l=0.5u
X392 zp_p lpopamp_core_0.sliceA_0.zp_m lpopamp_core_0.sliceA_0.yp_m avdd sg13_hv_pmos ad=1.125p pd=5u as=1.125p ps=5u w=4.5u l=0.5u
X393 lpopamp_core_0.sliceA_0.bpa_r lpopamp_core_0.sliceA_0.bpa_r a_9150_2500# avdd sg13_hv_pmos ad=1.125p pd=5u as=1.125p ps=5u w=4.5u l=0.5u
X394 a_23850_11850# lpopamp_core_0.sliceA_1.bpb lpopamp_core_0.sliceA_1.zn_m avdd sg13_hv_pmos ad=1.125p pd=5u as=1.125p ps=5u w=4.5u l=0.5u
X395 a_21650_700# lpopamp_core_0.sliceA_0.bna a_20050_100# avss sg13_hv_nmos ad=1.125p pd=5u as=1.125p ps=5u w=4.5u l=3.5u
X396 lpopamp_core_0.sliceB_1.enb en avdd avdd sg13_hv_pmos ad=1.125p pd=5u as=2.25p ps=10u w=4.5u l=1.5u
X397 a_15150_7150# in_m lpopamp_core_0.sliceB_0.yp_p avss sg13_hv_nmos ad=1.125p pd=5u as=1.125p ps=5u w=4.5u l=0.5u
X398 lpopamp_core_0.sliceB_1.bna lpopamp_core_0.sliceB_1.bna a_2850_8400# avss sg13_hv_nmos ad=1.125p pd=5u as=1.125p ps=5u w=4.5u l=3.5u
X399 a_7650_14250# lpopamp_core_0.sliceA_1.bna lpopamp_core_0.sliceA_1.bpb avss sg13_hv_nmos ad=1.125p pd=5u as=1.125p ps=5u w=4.5u l=3.5u
X400 a_26750_8400# lpopamp_core_0.sliceB_1.bnb zn_p avss sg13_hv_nmos ad=1.125p pd=5u as=1.125p ps=5u w=4.5u l=0.5u
X401 zp_p en avdd avdd sg13_hv_pmos ad=1.125p pd=5u as=1.125p ps=5u w=4.5u l=1.5u
X402 avss lpopamp_core_0.sliceA_0.enb zn_p avss sg13_hv_nmos ad=2.25p pd=10u as=1.125p ps=5u w=4.5u l=1.5u
X403 lpopamp_core_0.sliceB_1.zn_m lpopamp_core_0.sliceB_1.zn_m a_23350_8400# avss sg13_hv_nmos ad=1.125p pd=5u as=1.125p ps=5u w=4.5u l=0.5u
X404 lpopamp_core_0.sliceA_1.zn_m lpopamp_core_0.sliceA_1.bpb a_23850_11850# avdd sg13_hv_pmos ad=1.125p pd=5u as=1.125p ps=5u w=4.5u l=0.5u
X405 a_7650_8400# lpopamp_core_0.sliceB_1.bna lpopamp_core_0.sliceB_1.bpb avss sg13_hv_nmos ad=1.125p pd=5u as=1.125p ps=5u w=4.5u l=3.5u
X406 avss zn_p a_28750_7150# avss sg13_hv_nmos ad=1.125p pd=5u as=1.125p ps=5u w=4.5u l=0.5u
X407 a_9550_700# lpopamp_core_0.sliceA_0.bnb lpopamp_core_0.sliceA_0.bnb avss sg13_hv_nmos ad=1.125p pd=5u as=1.125p ps=5u w=4.5u l=0.5u
X408 lpopamp_core_0.sliceA_1.bpa lpopamp_core_0.sliceA_1.bpa avdd avdd sg13_hv_pmos ad=1.125p pd=5u as=1.125p ps=5u w=4.5u l=3.5u
X409 lpopamp_core_0.sliceA_1.yp_m lpopamp_core_0.sliceA_1.zp_m zp_p avdd sg13_hv_pmos ad=1.125p pd=5u as=1.125p ps=5u w=4.5u l=0.5u
X410 a_20150_8400# lpopamp_core_0.sliceB_1.bnb a_20050_7800# avss sg13_hv_nmos ad=1.125p pd=5u as=1.125p ps=5u w=4.5u l=0.5u
X411 avdd lpopamp_core_0.sliceA_0.bpa lpopamp_core_0.sliceA_0.bnb avdd sg13_hv_pmos ad=1.125p pd=5u as=1.125p ps=5u w=4.5u l=3.5u
X412 lpopamp_core_0.sliceA_1.bnb lpopamp_core_0.sliceA_1.bnb a_10550_14850# avss sg13_hv_nmos ad=1.125p pd=5u as=1.125p ps=5u w=4.5u l=0.5u
X413 avdd lpopamp_core_0.sliceA_1.bpa_l a_8750_12450# avdd sg13_hv_pmos ad=1.125p pd=5u as=1.125p ps=5u w=4.5u l=0.5u
X414 lpopamp_core_0.sliceA_1.xp in_m lpopamp_core_0.sliceA_1.yn_p avdd sg13_hv_pmos ad=1.125p pd=5u as=1.125p ps=5u w=4.5u l=0.5u
X415 a_23850_10200# lpopamp_core_0.sliceB_1.bpb lpopamp_core_0.sliceB_1.zn_m avdd sg13_hv_pmos ad=1.125p pd=5u as=1.125p ps=5u w=4.5u l=0.5u
X416 lpopamp_core_0.sliceB_0.bnb lpopamp_core_0.sliceB_0.bnb a_9350_7150# avss sg13_hv_nmos ad=1.125p pd=5u as=1.125p ps=5u w=4.5u l=0.5u
X417 a_25750_14850# lpopamp_core_0.sliceA_1.zn_m lpopamp_core_0.sliceA_1.yn_m avss sg13_hv_nmos ad=1.125p pd=5u as=1.125p ps=5u w=4.5u l=0.5u
X418 a_14550_14850# in_p lpopamp_core_0.sliceA_1.xn avss sg13_hv_nmos ad=1.125p pd=5u as=1.125p ps=5u w=4.5u l=0.5u
X419 lpopamp_core_0.sliceB_0.yp_m lpopamp_core_0.sliceB_0.zp_m avdd avdd sg13_hv_pmos ad=1.125p pd=5u as=1.125p ps=5u w=4.5u l=3.5u
X420 a_14750_7800# in_m lpopamp_core_0.sliceB_1.yp_p avss sg13_hv_nmos ad=1.125p pd=5u as=1.125p ps=5u w=4.5u l=0.5u
X421 avss zn_p a_29550_14850# avss sg13_hv_nmos ad=1.125p pd=5u as=1.125p ps=5u w=4.5u l=0.5u
X422 lpopamp_core_0.sliceB_1.yn_m in_p lpopamp_core_0.sliceB_1.xp avdd sg13_hv_pmos ad=1.125p pd=5u as=1.125p ps=5u w=4.5u l=0.5u
X423 avss lpopamp_core_0.sliceB_0.bna a_6050_7150# avss sg13_hv_nmos ad=1.125p pd=5u as=1.125p ps=5u w=4.5u l=3.5u
X424 avss zn_p a_29550_100# avss sg13_hv_nmos ad=1.125p pd=5u as=1.125p ps=5u w=4.5u l=0.5u
X425 lpopamp_core_0.sliceA_0.yn_p lpopamp_core_0.sliceA_0.zn_m a_22450_100# avss sg13_hv_nmos ad=1.125p pd=5u as=1.125p ps=5u w=4.5u l=3.5u
X426 lpopamp_core_0.sliceB_0.bpa_r lpopamp_core_0.sliceB_0.bpb lpopamp_core_0.sliceB_0.bpb avdd sg13_hv_pmos ad=1.125p pd=5u as=1.125p ps=5u w=4.5u l=0.5u
X427 lpopamp_core_0.sliceB_1.bnb lpopamp_core_0.sliceB_1.bnb a_11350_7800# avss sg13_hv_nmos ad=1.125p pd=5u as=1.125p ps=5u w=4.5u l=0.5u
X428 lpopamp_core_0.sliceB_0.yn_p in_m lpopamp_core_0.sliceB_0.xp avdd sg13_hv_pmos ad=1.125p pd=5u as=1.125p ps=5u w=4.5u l=0.5u
X429 lpopamp_core_0.sliceA_0.zn_m lpopamp_core_0.sliceA_0.bpb a_22450_2500# avdd sg13_hv_pmos ad=1.125p pd=5u as=1.125p ps=5u w=4.5u l=0.5u
X430 lpopamp_core_0.sliceA_0.bpa_l lpopamp_core_0.sliceA_0.bpa_l a_6750_3100# avdd sg13_hv_pmos ad=1.125p pd=5u as=1.125p ps=5u w=4.5u l=0.5u
X431 lpopamp_core_0.sliceA_1.bpa_l lpopamp_core_0.sliceA_1.bpb lpopamp_core_0.sliceA_1.bpb avdd sg13_hv_pmos ad=1.125p pd=5u as=1.125p ps=5u w=4.5u l=0.5u
X432 lpopamp_core_0.sliceB_0.bnb lpopamp_core_0.sliceB_0.bpa avdd avdd sg13_hv_pmos ad=1.125p pd=5u as=1.125p ps=5u w=4.5u l=3.5u
X433 avdd lpopamp_core_0.sliceA_0.tihi lpopamp_core_0.sliceA_0.tihi avdd sg13_hv_pmos ad=1.125p pd=5u as=1.125p ps=5u w=4.5u l=9.5u
X434 lpopamp_core_0.sliceB_0.bnb lpopamp_core_0.sliceB_0.bnb a_10150_6550# avss sg13_hv_nmos ad=1.125p pd=5u as=1.125p ps=5u w=4.5u l=0.5u
X435 lpopamp_core_0.sliceA_1.bnb lpopamp_core_0.sliceA_1.bnb a_9350_14850# avss sg13_hv_nmos ad=1.125p pd=5u as=1.125p ps=5u w=4.5u l=0.5u
X436 lpopamp_core_0.sliceB_1.bpb lpopamp_core_0.sliceB_1.bpb lpopamp_core_0.sliceB_1.bpa_l avdd sg13_hv_pmos ad=1.125p pd=5u as=1.125p ps=5u w=4.5u l=0.5u
X437 zp_p lpopamp_core_0.sliceA_0.zp_m lpopamp_core_0.sliceA_0.yp_m avdd sg13_hv_pmos ad=1.125p pd=5u as=1.125p ps=5u w=4.5u l=0.5u
X438 lpopamp_core_0.sliceA_0.yp_m in_p a_14950_700# avss sg13_hv_nmos ad=1.125p pd=5u as=1.125p ps=5u w=4.5u l=0.5u
X439 a_14750_100# in_p lpopamp_core_0.sliceA_0.yp_m avss sg13_hv_nmos ad=1.125p pd=5u as=1.125p ps=5u w=4.5u l=0.5u
X440 avdd en lpopamp_core_0.sliceB_0.bpa avdd sg13_hv_pmos ad=1.125p pd=5u as=1.125p ps=5u w=4.5u l=1.5u
X441 a_6050_7800# lpopamp_core_0.sliceB_1.bna lpopamp_core_0.sliceB_1.bpa avss sg13_hv_nmos ad=1.125p pd=5u as=1.125p ps=5u w=4.5u l=3.5u
X442 lpopamp_core_0.sliceB_1.zp_m lpopamp_core_0.sliceB_1.zp_m lpopamp_core_0.sliceB_1.yp_p avdd sg13_hv_pmos ad=1.125p pd=5u as=1.125p ps=5u w=4.5u l=0.5u
X443 lpopamp_core_0.sliceB_1.bpb lpopamp_core_0.sliceB_1.bpb lpopamp_core_0.sliceB_1.bpa_r avdd sg13_hv_pmos ad=1.125p pd=5u as=1.125p ps=5u w=4.5u l=0.5u
X444 a_23850_2500# lpopamp_core_0.sliceA_0.bpb lpopamp_core_0.sliceA_0.zn_m avdd sg13_hv_pmos ad=1.125p pd=5u as=1.125p ps=5u w=4.5u l=0.5u
X445 out zp_p avdd avdd sg13_hv_pmos ad=1.125p pd=5u as=1.125p ps=5u w=4.5u l=0.5u
X446 a_29550_7800# zn_p out avss sg13_hv_nmos ad=1.125p pd=5u as=1.125p ps=5u w=4.5u l=0.5u
X447 lpopamp_core_0.sliceA_1.bnb lpopamp_core_0.sliceA_1.bnb a_11350_14250# avss sg13_hv_nmos ad=1.125p pd=5u as=1.125p ps=5u w=4.5u l=0.5u
X448 lpopamp_core_0.sliceA_0.zn_m lpopamp_core_0.sliceA_0.zn_m a_23750_700# avss sg13_hv_nmos ad=1.125p pd=5u as=1.125p ps=5u w=4.5u l=0.5u
X449 a_10950_2500# lpopamp_core_0.sliceA_0.bpa_r lpopamp_core_0.sliceA_0.bpa_r avdd sg13_hv_pmos ad=1.125p pd=5u as=1.125p ps=5u w=4.5u l=0.5u
X450 a_8950_4150# lpopamp_core_0.sliceB_0.bpa_r avdd avdd sg13_hv_pmos ad=1.125p pd=5u as=1.125p ps=5u w=4.5u l=0.5u
X451 a_26550_14250# lpopamp_core_0.sliceA_1.bnb zp_p avss sg13_hv_nmos ad=1.125p pd=5u as=1.125p ps=5u w=4.5u l=0.5u
X452 a_23950_6550# lpopamp_core_0.sliceB_0.zn_m lpopamp_core_0.sliceB_0.zn_m avss sg13_hv_nmos ad=1.125p pd=5u as=1.125p ps=5u w=4.5u l=0.5u
X453 a_15650_14250# lpopamp_core_0.sliceA_1.bna lpopamp_core_0.sliceA_1.xn avss sg13_hv_nmos ad=1.125p pd=5u as=1.125p ps=5u w=4.5u l=3.5u
X454 out zp_p avdd avdd sg13_hv_pmos ad=1.125p pd=5u as=1.125p ps=5u w=4.5u l=0.5u
X455 lpopamp_core_0.sliceA_0.xp in_p lpopamp_core_0.sliceA_0.yn_m avdd sg13_hv_pmos ad=1.125p pd=5u as=1.125p ps=5u w=4.5u l=0.5u
X456 avdd lpopamp_core_0.sliceB_0.zp_m lpopamp_core_0.sliceB_0.yp_p avdd sg13_hv_pmos ad=1.125p pd=5u as=1.125p ps=5u w=4.5u l=3.5u
X457 a_9150_4750# lpopamp_core_0.sliceB_0.bpa_r a_9050_4750# avdd sg13_hv_pmos ad=1.125p pd=5u as=1.125p ps=5u w=4.5u l=0.5u
X458 zn_p lpopamp_core_0.sliceB_1.zn_m a_26150_7800# avss sg13_hv_nmos ad=1.125p pd=5u as=1.125p ps=5u w=4.5u l=0.5u
X459 lpopamp_core_0.sliceA_0.yn_p lpopamp_core_0.sliceA_0.zn_m a_23950_100# avss sg13_hv_nmos ad=1.125p pd=5u as=1.125p ps=5u w=4.5u l=0.5u
X460 avdd en zp_p avdd sg13_hv_pmos ad=2.25p pd=10u as=1.125p ps=5u w=4.5u l=1.5u
X461 lpopamp_core_0.sliceB_0.zp_m lpopamp_core_0.sliceB_0.bnb a_20550_6550# avss sg13_hv_nmos ad=1.125p pd=5u as=1.125p ps=5u w=4.5u l=0.5u
X462 lpopamp_core_0.sliceB_0.bna lpopamp_core_0.sliceB_0.enb avss avss sg13_hv_nmos ad=1.125p pd=5u as=1.125p ps=5u w=4.5u l=1.5u
X463 lpopamp_core_0.sliceA_0.yp_m lpopamp_core_0.sliceA_0.zp_m avdd avdd sg13_hv_pmos ad=1.125p pd=5u as=1.125p ps=5u w=4.5u l=3.5u
X464 a_29450_4150# zp_p out avdd sg13_hv_pmos ad=1.125p pd=5u as=1.125p ps=5u w=4.5u l=0.5u
X465 avdd en lpopamp_core_0.sliceB_0.enb avdd sg13_hv_pmos ad=1.125p pd=5u as=1.125p ps=5u w=4.5u l=1.5u
X466 a_22450_11850# lpopamp_core_0.sliceA_1.bpb lpopamp_core_0.sliceA_1.zn_m avdd sg13_hv_pmos ad=1.125p pd=5u as=1.125p ps=5u w=4.5u l=0.5u
X467 zp_p lpopamp_core_0.sliceB_0.zp_m lpopamp_core_0.sliceB_0.yp_m avdd sg13_hv_pmos ad=1.125p pd=5u as=1.125p ps=5u w=4.5u l=0.5u
X468 lpopamp_core_0.sliceA_1.yp_p lpopamp_core_0.sliceA_1.zp_m avdd avdd sg13_hv_pmos ad=1.125p pd=5u as=1.125p ps=5u w=4.5u l=3.5u
X469 lpopamp_core_0.sliceA_1.xp in_m lpopamp_core_0.sliceA_1.yn_p avdd sg13_hv_pmos ad=1.125p pd=5u as=1.125p ps=5u w=4.5u l=0.5u
X470 a_5250_700# lpopamp_core_0.sliceA_0.bna avss avss sg13_hv_nmos ad=1.125p pd=5u as=1.125p ps=5u w=4.5u l=3.5u
X471 zp_p lpopamp_core_0.sliceA_0.bpb zn_p avdd sg13_hv_pmos ad=1.125p pd=5u as=1.125p ps=5u w=4.5u l=0.5u
X472 lpopamp_core_0.sliceA_0.bpa_r lpopamp_core_0.sliceA_0.bpb lpopamp_core_0.sliceA_0.bpb avdd sg13_hv_pmos ad=1.125p pd=5u as=1.125p ps=5u w=4.5u l=0.5u
X473 lpopamp_core_0.sliceA_1.zn_m lpopamp_core_0.sliceA_1.bpb a_22450_11850# avdd sg13_hv_pmos ad=1.125p pd=5u as=1.125p ps=5u w=4.5u l=0.5u
X474 avdd lpopamp_core_0.sliceA_1.bpa lpopamp_core_0.sliceA_1.bnb avdd sg13_hv_pmos ad=1.125p pd=5u as=1.125p ps=5u w=4.5u l=3.5u
X475 lpopamp_core_0.sliceA_0.yn_m lpopamp_core_0.sliceA_0.zn_m a_25250_700# avss sg13_hv_nmos ad=1.125p pd=5u as=1.125p ps=5u w=4.5u l=3.5u
X476 a_20050_14250# lpopamp_core_0.sliceA_1.bnb a_20750_14850# avss sg13_hv_nmos ad=1.125p pd=5u as=1.125p ps=5u w=4.5u l=0.5u
X477 avss zn_p a_29950_7800# avss sg13_hv_nmos ad=1.125p pd=5u as=1.125p ps=5u w=4.5u l=0.5u
X478 a_10150_8400# lpopamp_core_0.sliceB_1.bnb lpopamp_core_0.sliceB_1.bna_ avss sg13_hv_nmos ad=1.125p pd=5u as=1.125p ps=5u w=4.5u l=0.5u
X479 lpopamp_core_0.sliceA_1.bpa_l lpopamp_core_0.sliceA_1.bpb lpopamp_core_0.sliceA_1.bpb avdd sg13_hv_pmos ad=1.125p pd=5u as=1.125p ps=5u w=4.5u l=0.5u
X480 out zn_p a_28550_14850# avss sg13_hv_nmos ad=1.125p pd=5u as=1.125p ps=5u w=4.5u l=0.5u
X481 zp_p lpopamp_core_0.sliceB_1.zp_m lpopamp_core_0.sliceB_1.yp_m avdd sg13_hv_pmos ad=1.125p pd=5u as=1.125p ps=5u w=4.5u l=0.5u
X482 a_12250_7150# lpopamp_core_0.sliceB_0.bna_ a_12150_7150# avss sg13_hv_nmos ad=1.125p pd=5u as=1.125p ps=5u w=4.5u l=0.5u
X483 lpopamp_core_0.sliceB_1.xp lpopamp_core_0.sliceB_1.bpa avdd avdd sg13_hv_pmos ad=1.125p pd=5u as=1.125p ps=5u w=4.5u l=3.5u
X484 avss lpopamp_core_0.sliceB_1.bna a_7650_8400# avss sg13_hv_nmos ad=1.125p pd=5u as=1.125p ps=5u w=4.5u l=3.5u
X485 lpopamp_core_0.sliceB_1.zn_m lpopamp_core_0.sliceB_1.zn_m a_23750_8400# avss sg13_hv_nmos ad=1.125p pd=5u as=1.125p ps=5u w=4.5u l=0.5u
X486 lpopamp_core_0.sliceA_0.yp_p lpopamp_core_0.sliceA_0.zp_m avdd avdd sg13_hv_pmos ad=1.125p pd=5u as=1.125p ps=5u w=4.5u l=3.5u
X487 a_20550_8400# lpopamp_core_0.sliceB_1.bnb a_20050_7800# avss sg13_hv_nmos ad=1.125p pd=5u as=1.125p ps=5u w=4.5u l=0.5u
X488 lpopamp_core_0.sliceA_0.bna_ lpopamp_core_0.sliceA_0.bnb a_10350_700# avss sg13_hv_nmos ad=1.125p pd=5u as=1.125p ps=5u w=4.5u l=0.5u
X489 a_25950_7150# lpopamp_core_0.sliceB_0.zn_m zn_p avss sg13_hv_nmos ad=1.125p pd=5u as=1.125p ps=5u w=4.5u l=0.5u
X490 a_6650_11850# lpopamp_core_0.sliceA_1.bpa_l a_6550_11850# avdd sg13_hv_pmos ad=1.125p pd=5u as=1.125p ps=5u w=4.5u l=0.5u
X491 lpopamp_core_0.sliceB_0.bnb lpopamp_core_0.sliceB_0.bnb a_9750_7150# avss sg13_hv_nmos ad=1.125p pd=5u as=1.125p ps=5u w=4.5u l=0.5u
X492 lpopamp_core_0.sliceA_1.bna lpopamp_core_0.sliceA_1.enb avss avss sg13_hv_nmos ad=1.125p pd=5u as=1.125p ps=5u w=4.5u l=1.5u
X493 a_6850_7150# lpopamp_core_0.sliceB_0.bna avss avss sg13_hv_nmos ad=1.125p pd=5u as=1.125p ps=5u w=4.5u l=3.5u
X494 lpopamp_core_0.sliceB_1.bpb lpopamp_core_0.sliceB_1.bpb lpopamp_core_0.sliceB_1.bpa_l avdd sg13_hv_pmos ad=1.125p pd=5u as=1.125p ps=5u w=4.5u l=0.5u
X495 a_8450_14850# lpopamp_core_0.sliceA_1.bna_ a_8350_14850# avss sg13_hv_nmos ad=1.125p pd=5u as=1.125p ps=5u w=4.5u l=0.5u
X496 a_26550_100# lpopamp_core_0.sliceA_0.bnb zp_p avss sg13_hv_nmos ad=1.125p pd=5u as=1.125p ps=5u w=4.5u l=0.5u
X497 avdd lpopamp_core_0.sliceA_0.bpa lpopamp_core_0.sliceA_0.xp avdd sg13_hv_pmos ad=1.125p pd=5u as=1.125p ps=5u w=4.5u l=3.5u
X498 lpopamp_core_0.sliceB_0.bpa_r lpopamp_core_0.sliceB_0.bpb lpopamp_core_0.sliceB_0.bpb avdd sg13_hv_pmos ad=1.125p pd=5u as=1.125p ps=5u w=4.5u l=0.5u
X499 lpopamp_core_0.sliceB_1.bnb lpopamp_core_0.sliceB_1.bnb a_11750_7800# avss sg13_hv_nmos ad=1.125p pd=5u as=1.125p ps=5u w=4.5u l=0.5u
X500 avdd lpopamp_core_0.sliceB_1.zp_m lpopamp_core_0.sliceB_1.yp_p avdd sg13_hv_pmos ad=1.125p pd=5u as=1.125p ps=5u w=4.5u l=3.5u
X501 lpopamp_core_0.sliceB_0.yn_p in_m lpopamp_core_0.sliceB_0.xp avdd sg13_hv_pmos ad=1.125p pd=5u as=1.125p ps=5u w=4.5u l=0.5u
X502 zn_p lpopamp_core_0.sliceB_0.bnb a_26950_7150# avss sg13_hv_nmos ad=1.125p pd=5u as=1.125p ps=5u w=4.5u l=0.5u
X503 lpopamp_core_0.sliceA_1.bna_ lpopamp_core_0.sliceA_1.bnb a_10350_14250# avss sg13_hv_nmos ad=1.125p pd=5u as=1.125p ps=5u w=4.5u l=0.5u
X504 a_23850_10200# lpopamp_core_0.sliceB_1.bpb lpopamp_core_0.sliceB_1.zn_m avdd sg13_hv_pmos ad=1.125p pd=5u as=1.125p ps=5u w=4.5u l=0.5u
X505 a_13950_6550# in_p lpopamp_core_0.sliceB_0.yp_m avss sg13_hv_nmos ad=1.125p pd=5u as=1.125p ps=5u w=4.5u l=0.5u
X506 a_14350_14250# in_m lpopamp_core_0.sliceA_1.yp_p avss sg13_hv_nmos ad=1.125p pd=5u as=1.125p ps=5u w=4.5u l=0.5u
X507 avdd lpopamp_core_0.sliceB_1.zp_m lpopamp_core_0.sliceB_1.yp_m avdd sg13_hv_pmos ad=1.125p pd=5u as=1.125p ps=5u w=4.5u l=3.5u
X508 avdd lpopamp_core_0.sliceB_0.bpa lpopamp_core_0.sliceB_0.bnb avdd sg13_hv_pmos ad=1.125p pd=5u as=1.125p ps=5u w=4.5u l=3.5u
X509 out zn_p a_29350_14250# avss sg13_hv_nmos ad=1.125p pd=5u as=1.125p ps=5u w=4.5u l=0.5u
X510 lpopamp_core_0.sliceB_0.bnb lpopamp_core_0.sliceB_0.bnb a_10550_6550# avss sg13_hv_nmos ad=1.125p pd=5u as=1.125p ps=5u w=4.5u l=0.5u
X511 zp_p lpopamp_core_0.sliceA_0.bpb zn_p avdd sg13_hv_pmos ad=1.125p pd=5u as=1.125p ps=5u w=4.5u l=0.5u
X512 lpopamp_core_0.sliceA_0.bna_ lpopamp_core_0.sliceA_0.bnb a_11550_100# avss sg13_hv_nmos ad=1.125p pd=5u as=1.125p ps=5u w=4.5u l=0.5u
X513 lpopamp_core_0.sliceB_0.xp lpopamp_core_0.sliceB_0.bpa avdd avdd sg13_hv_pmos ad=1.125p pd=5u as=1.125p ps=5u w=4.5u l=3.5u
X514 a_23850_2500# lpopamp_core_0.sliceA_0.bpb lpopamp_core_0.sliceA_0.zn_m avdd sg13_hv_pmos ad=1.125p pd=5u as=1.125p ps=5u w=4.5u l=0.5u
X515 lpopamp_core_0.sliceA_0.bpb lpopamp_core_0.sliceA_0.bpb lpopamp_core_0.sliceA_0.bpa_l avdd sg13_hv_pmos ad=1.125p pd=5u as=1.125p ps=5u w=4.5u l=0.5u
X516 out zp_p avdd avdd sg13_hv_pmos ad=1.125p pd=5u as=1.125p ps=5u w=4.5u l=0.5u
X517 a_29950_7800# zn_p out avss sg13_hv_nmos ad=1.125p pd=5u as=1.125p ps=5u w=4.5u l=0.5u
X518 lpopamp_core_0.sliceB_0.yp_p in_m a_14950_6550# avss sg13_hv_nmos ad=1.125p pd=5u as=1.125p ps=5u w=4.5u l=0.5u
X519 a_20750_700# lpopamp_core_0.sliceA_0.bnb lpopamp_core_0.sliceA_0.zp_m avss sg13_hv_nmos ad=1.125p pd=5u as=1.125p ps=5u w=4.5u l=0.5u
X520 lpopamp_core_0.sliceA_0.zp_m lpopamp_core_0.sliceA_0.zp_m lpopamp_core_0.sliceA_0.yp_p avdd sg13_hv_pmos ad=1.125p pd=5u as=1.125p ps=5u w=4.5u l=0.5u
X521 zn_p lpopamp_core_0.sliceB_0.bpb zp_p avdd sg13_hv_pmos ad=1.125p pd=5u as=1.125p ps=5u w=4.5u l=0.5u
X522 lpopamp_core_0.sliceB_0.bpb lpopamp_core_0.sliceB_0.bpb lpopamp_core_0.sliceB_0.bpa_r avdd sg13_hv_pmos ad=1.125p pd=5u as=1.125p ps=5u w=4.5u l=0.5u
X523 zn_p lpopamp_core_0.sliceB_1.bnb a_26550_7800# avss sg13_hv_nmos ad=1.125p pd=5u as=1.125p ps=5u w=4.5u l=0.5u
X524 lpopamp_core_0.sliceA_1.bpa lpopamp_core_0.sliceA_1.bna a_5250_14250# avss sg13_hv_nmos ad=1.125p pd=5u as=1.125p ps=5u w=4.5u l=3.5u
X525 lpopamp_core_0.sliceA_1.zp_m lpopamp_core_0.sliceA_1.zp_m lpopamp_core_0.sliceA_1.yp_p avdd sg13_hv_pmos ad=1.125p pd=5u as=1.125p ps=5u w=4.5u l=0.5u
X526 a_5250_6550# lpopamp_core_0.sliceB_0.bna avss avss sg13_hv_nmos ad=1.125p pd=5u as=1.125p ps=5u w=4.5u l=3.5u
X527 lpopamp_core_0.sliceA_1.bna_ lpopamp_core_0.sliceA_1.bnb a_9150_14250# avss sg13_hv_nmos ad=1.125p pd=5u as=1.125p ps=5u w=4.5u l=0.5u
X528 a_29850_4150# zp_p out avdd sg13_hv_pmos ad=1.125p pd=5u as=1.125p ps=5u w=4.5u l=0.5u
X529 avdd lpopamp_core_0.sliceA_0.bpa lpopamp_core_0.sliceA_0.yp_m avdd sg13_hv_pmos ad=1.125p pd=5u as=1.125p ps=5u w=4.5u l=3.5u
X530 a_23350_7800# lpopamp_core_0.sliceB_1.zn_m lpopamp_core_0.sliceB_1.yn_p avss sg13_hv_nmos ad=1.125p pd=5u as=1.125p ps=5u w=4.5u l=0.5u
X531 avss zn_p a_29950_700# avss sg13_hv_nmos ad=1.125p pd=5u as=1.125p ps=5u w=4.5u l=0.5u
X532 a_28750_6550# zn_p out avss sg13_hv_nmos ad=1.125p pd=5u as=1.125p ps=5u w=4.5u l=0.5u
X533 lpopamp_core_0.sliceA_1.bpb lpopamp_core_0.sliceA_1.bpb lpopamp_core_0.sliceA_1.bpa_r avdd sg13_hv_pmos ad=1.125p pd=5u as=1.125p ps=5u w=4.5u l=0.5u
X534 zn_p lpopamp_core_0.sliceA_1.bpb zp_p avdd sg13_hv_pmos ad=1.125p pd=5u as=1.125p ps=5u w=4.5u l=0.5u
X535 a_9350_6550# lpopamp_core_0.sliceB_0.bnb lpopamp_core_0.sliceB_0.bna_ avss sg13_hv_nmos ad=1.125p pd=5u as=1.125p ps=5u w=4.5u l=0.5u
X536 lpopamp_core_0.sliceA_1.bpa_l lpopamp_core_0.sliceA_1.bpa_l a_6750_12450# avdd sg13_hv_pmos ad=1.125p pd=5u as=1.125p ps=5u w=4.5u l=0.5u
X537 a_8950_700# lpopamp_core_0.sliceA_0.bnb lpopamp_core_0.sliceA_0.bna_ avss sg13_hv_nmos ad=1.125p pd=5u as=1.125p ps=5u w=4.5u l=0.5u
X538 a_23750_14850# lpopamp_core_0.sliceA_1.zn_m lpopamp_core_0.sliceA_1.yn_p avss sg13_hv_nmos ad=1.125p pd=5u as=1.125p ps=5u w=4.5u l=0.5u
X539 out zp_p avdd avdd sg13_hv_pmos ad=1.125p pd=5u as=1.125p ps=5u w=4.5u l=0.5u
X540 a_13250_700# lpopamp_core_0.sliceA_0.bna avss avss sg13_hv_nmos ad=1.125p pd=5u as=1.125p ps=5u w=4.5u l=3.5u
X541 lpopamp_core_0.sliceB_0.bpb lpopamp_core_0.sliceB_0.bpb lpopamp_core_0.sliceB_0.bpa_l avdd sg13_hv_pmos ad=1.125p pd=5u as=1.125p ps=5u w=4.5u l=0.5u
X542 a_12550_14850# lpopamp_core_0.sliceA_1.bna_ a_12450_14850# avss sg13_hv_nmos ad=1.125p pd=5u as=1.125p ps=5u w=4.5u l=0.5u
X543 lpopamp_core_0.sliceA_1.yn_m in_p lpopamp_core_0.sliceA_1.xp avdd sg13_hv_pmos ad=1.125p pd=5u as=1.125p ps=5u w=4.5u l=0.5u
X544 avdd lpopamp_core_0.sliceB_1.bpa_r a_11150_10800# avdd sg13_hv_pmos ad=1.125p pd=5u as=1.125p ps=5u w=4.5u l=0.5u
X545 a_22450_6550# lpopamp_core_0.sliceB_0.zn_m avss avss sg13_hv_nmos ad=1.125p pd=5u as=1.125p ps=5u w=4.5u l=3.5u
X546 lpopamp_core_0.sliceA_1.yn_m lpopamp_core_0.sliceA_1.zn_m a_27550_14850# avss sg13_hv_nmos ad=1.125p pd=5u as=1.125p ps=5u w=4.5u l=0.5u
X547 avdd lpopamp_core_0.sliceB_1.zp_m lpopamp_core_0.sliceB_1.yp_m avdd sg13_hv_pmos ad=1.125p pd=5u as=1.125p ps=5u w=4.5u l=3.5u
X548 a_9150_100# lpopamp_core_0.sliceA_0.bnb lpopamp_core_0.sliceA_0.bnb avss sg13_hv_nmos ad=1.125p pd=5u as=1.125p ps=5u w=4.5u l=0.5u
X549 lpopamp_core_0.sliceB_1.yp_m in_p a_13750_8400# avss sg13_hv_nmos ad=1.125p pd=5u as=1.125p ps=5u w=4.5u l=0.5u
X550 a_29350_700# zn_p avss avss sg13_hv_nmos ad=1.125p pd=5u as=1.125p ps=5u w=4.5u l=0.5u
X551 a_22450_2500# lpopamp_core_0.sliceA_0.bpb lpopamp_core_0.sliceA_0.zn_m avdd sg13_hv_pmos ad=1.125p pd=5u as=1.125p ps=5u w=4.5u l=0.5u
X552 a_10550_8400# lpopamp_core_0.sliceB_1.bnb lpopamp_core_0.sliceB_1.bna_ avss sg13_hv_nmos ad=1.125p pd=5u as=1.125p ps=5u w=4.5u l=0.5u
X553 a_6750_2500# lpopamp_core_0.sliceA_0.bpa_l a_6650_2500# avdd sg13_hv_pmos ad=1.125p pd=5u as=1.125p ps=5u w=4.5u l=0.5u
X554 lpopamp_core_0.sliceA_1.bna en ib avss sg13_hv_nmos ad=1.125p pd=5u as=1.125p ps=5u w=4.5u l=1.5u
X555 lpopamp_core_0.sliceA_1.bpb lpopamp_core_0.sliceA_1.bpb lpopamp_core_0.sliceA_1.bpa_r avdd sg13_hv_pmos ad=1.125p pd=5u as=1.125p ps=5u w=4.5u l=0.5u
X556 a_12650_7150# lpopamp_core_0.sliceB_0.bna_ a_12550_7150# avss sg13_hv_nmos ad=1.125p pd=5u as=1.125p ps=5u w=4.5u l=0.5u
X557 avdd lpopamp_core_0.sliceB_1.bpa lpopamp_core_0.sliceB_1.bpa avdd sg13_hv_pmos ad=1.125p pd=5u as=1.125p ps=5u w=4.5u l=3.5u
X558 lpopamp_core_0.sliceA_0.yp_m lpopamp_core_0.sliceA_0.zp_m zp_p avdd sg13_hv_pmos ad=1.125p pd=5u as=1.125p ps=5u w=4.5u l=0.5u
X559 avdd en zp_p avdd sg13_hv_pmos ad=2.25p pd=10u as=1.125p ps=5u w=4.5u l=1.5u
X560 lpopamp_core_0.sliceA_1.zp_m lpopamp_core_0.sliceA_1.bnb a_20550_14250# avss sg13_hv_nmos ad=1.125p pd=5u as=1.125p ps=5u w=4.5u l=0.5u
X561 ib en lpopamp_core_0.sliceA_0.bna avss sg13_hv_nmos ad=1.125p pd=5u as=1.125p ps=5u w=4.5u l=1.5u
X562 a_20950_8400# lpopamp_core_0.sliceB_1.bnb a_20050_7800# avss sg13_hv_nmos ad=1.125p pd=5u as=1.125p ps=5u w=4.5u l=0.5u
X563 lpopamp_core_0.sliceA_0.xn in_m a_14350_700# avss sg13_hv_nmos ad=1.125p pd=5u as=1.125p ps=5u w=4.5u l=0.5u
X564 avss lpopamp_core_0.sliceA_1.zn_m a_24450_14250# avss sg13_hv_nmos ad=1.125p pd=5u as=1.125p ps=5u w=4.5u l=3.5u
X565 lpopamp_core_0.sliceA_1.xn lpopamp_core_0.sliceA_1.bna a_13250_14250# avss sg13_hv_nmos ad=1.125p pd=5u as=1.125p ps=5u w=4.5u l=3.5u
X566 zp_p lpopamp_core_0.sliceB_1.zp_m lpopamp_core_0.sliceB_1.yp_m avdd sg13_hv_pmos ad=1.125p pd=5u as=1.125p ps=5u w=4.5u l=0.5u
X567 out zn_p a_28550_8400# avss sg13_hv_nmos ad=1.125p pd=5u as=1.125p ps=5u w=4.5u l=0.5u
X568 lpopamp_core_0.sliceB_0.bpb lpopamp_core_0.sliceB_0.bna a_6850_7150# avss sg13_hv_nmos ad=1.125p pd=5u as=1.125p ps=5u w=4.5u l=3.5u
X569 lpopamp_core_0.sliceB_1.yn_m lpopamp_core_0.sliceB_1.zn_m a_25250_8400# avss sg13_hv_nmos ad=1.125p pd=5u as=1.125p ps=5u w=4.5u l=3.5u
X570 lpopamp_core_0.sliceA_0.xp lpopamp_core_0.sliceA_0.bpa avdd avdd sg13_hv_pmos ad=1.125p pd=5u as=1.125p ps=5u w=4.5u l=3.5u
X571 lpopamp_core_0.sliceB_1.bna_ lpopamp_core_0.sliceB_1.bnb a_9150_8400# avss sg13_hv_nmos ad=1.125p pd=5u as=1.125p ps=5u w=4.5u l=0.5u
X572 lpopamp_core_0.sliceA_0.zn_m lpopamp_core_0.sliceA_0.zn_m a_23350_100# avss sg13_hv_nmos ad=1.125p pd=5u as=1.125p ps=5u w=4.5u l=0.5u
X573 a_10950_12450# lpopamp_core_0.sliceA_1.bpa_r lpopamp_core_0.sliceA_1.bpa_r avdd sg13_hv_pmos ad=1.125p pd=5u as=1.125p ps=5u w=4.5u l=0.5u
X574 avdd lpopamp_core_0.sliceB_0.bpa lpopamp_core_0.sliceB_0.xp avdd sg13_hv_pmos ad=1.125p pd=5u as=1.125p ps=5u w=4.5u l=3.5u
X575 zn_p lpopamp_core_0.sliceB_0.zn_m a_27350_7150# avss sg13_hv_nmos ad=1.125p pd=5u as=1.125p ps=5u w=4.5u l=0.5u
X576 out zp_p avdd avdd sg13_hv_pmos ad=1.125p pd=5u as=1.125p ps=5u w=4.5u l=0.5u
X577 a_11150_3100# lpopamp_core_0.sliceA_0.bpa_r a_11050_3100# avdd sg13_hv_pmos ad=1.125p pd=5u as=1.125p ps=5u w=4.5u l=0.5u
X578 lpopamp_core_0.sliceA_1.yn_m in_p lpopamp_core_0.sliceA_1.xp avdd sg13_hv_pmos ad=1.125p pd=5u as=1.125p ps=5u w=4.5u l=0.5u
X579 a_24450_7150# lpopamp_core_0.sliceB_0.zn_m lpopamp_core_0.sliceB_0.yn_p avss sg13_hv_nmos ad=1.125p pd=5u as=1.125p ps=5u w=4.5u l=3.5u
X580 a_8250_14250# lpopamp_core_0.sliceA_1.bna_ a_8150_14250# avss sg13_hv_nmos ad=1.125p pd=5u as=1.125p ps=5u w=4.5u l=0.5u
X581 lpopamp_core_0.sliceB_0.yp_p lpopamp_core_0.sliceB_0.zp_m lpopamp_core_0.sliceB_0.zp_m avdd sg13_hv_pmos ad=1.125p pd=5u as=1.125p ps=5u w=4.5u l=0.5u
X582 lpopamp_core_0.sliceB_1.xn lpopamp_core_0.sliceB_1.bna a_13250_7800# avss sg13_hv_nmos ad=1.125p pd=5u as=1.125p ps=5u w=4.5u l=3.5u
X583 lpopamp_core_0.sliceA_0.bna lpopamp_core_0.sliceA_0.enb avss avss sg13_hv_nmos ad=1.125p pd=5u as=1.125p ps=5u w=4.5u l=1.5u
X584 lpopamp_core_0.sliceB_0.yn_m in_p lpopamp_core_0.sliceB_0.xp avdd sg13_hv_pmos ad=1.125p pd=5u as=1.125p ps=5u w=4.5u l=0.5u
X585 a_8750_3100# lpopamp_core_0.sliceA_0.bpa_l a_8650_3100# avdd sg13_hv_pmos ad=1.125p pd=5u as=1.125p ps=5u w=4.5u l=0.5u
X586 lpopamp_core_0.sliceB_1.bna_ lpopamp_core_0.sliceB_1.bnb a_9950_7800# avss sg13_hv_nmos ad=1.125p pd=5u as=1.125p ps=5u w=4.5u l=0.5u
X587 lpopamp_core_0.sliceB_1.yp_p lpopamp_core_0.sliceB_1.zp_m lpopamp_core_0.sliceB_1.zp_m avdd sg13_hv_pmos ad=1.125p pd=5u as=1.125p ps=5u w=4.5u l=0.5u
X588 out zp_p a_28650_11850# avdd sg13_hv_pmos ad=1.125p pd=5u as=1.125p ps=5u w=4.5u l=0.5u
X589 lpopamp_core_0.sliceA_0.zp_m lpopamp_core_0.sliceA_0.zp_m lpopamp_core_0.sliceA_0.yp_p avdd sg13_hv_pmos ad=1.125p pd=5u as=1.125p ps=5u w=4.5u l=0.5u
X590 a_11550_14850# lpopamp_core_0.sliceA_1.bnb lpopamp_core_0.sliceA_1.bnb avss sg13_hv_nmos ad=1.125p pd=5u as=1.125p ps=5u w=4.5u l=0.5u
X591 lpopamp_core_0.sliceB_1.bpa_r lpopamp_core_0.sliceB_1.bpb lpopamp_core_0.sliceB_1.bpb avdd sg13_hv_pmos ad=1.125p pd=5u as=1.125p ps=5u w=4.5u l=0.5u
X592 zp_p lpopamp_core_0.sliceB_1.zp_m lpopamp_core_0.sliceB_1.yp_m avdd sg13_hv_pmos ad=1.125p pd=5u as=1.125p ps=5u w=4.5u l=0.5u
X593 lpopamp_core_0.sliceB_0.bpb lpopamp_core_0.sliceB_0.bpb lpopamp_core_0.sliceB_0.bpa_r avdd sg13_hv_pmos ad=1.125p pd=5u as=1.125p ps=5u w=4.5u l=0.5u
X594 a_12150_6550# lpopamp_core_0.sliceB_0.bna_ lpopamp_core_0.sliceB_0.bna_ avss sg13_hv_nmos ad=1.125p pd=5u as=1.125p ps=5u w=4.5u l=0.5u
X595 zn_p lpopamp_core_0.sliceA_1.bnb a_26550_14850# avss sg13_hv_nmos ad=1.125p pd=5u as=1.125p ps=5u w=4.5u l=0.5u
X596 lpopamp_core_0.sliceA_1.bpb lpopamp_core_0.sliceA_1.bpb lpopamp_core_0.sliceA_1.bpa_r avdd sg13_hv_pmos ad=1.125p pd=5u as=1.125p ps=5u w=4.5u l=0.5u
X597 avdd lpopamp_core_0.sliceB_1.zp_m lpopamp_core_0.sliceB_1.yp_m avdd sg13_hv_pmos ad=1.125p pd=5u as=1.125p ps=5u w=4.5u l=3.5u
X598 avdd zp_p out avdd sg13_hv_pmos ad=1.125p pd=5u as=1.125p ps=5u w=4.5u l=0.5u
X599 avdd zp_p out avdd sg13_hv_pmos ad=1.125p pd=5u as=1.125p ps=5u w=4.5u l=0.5u
X600 lpopamp_core_0.sliceA_0.enb en avdd avdd sg13_hv_pmos ad=1.125p pd=5u as=2.25p ps=10u w=4.5u l=1.5u
X601 lpopamp_core_0.sliceB_0.zn_m lpopamp_core_0.sliceB_0.bpb a_22450_4150# avdd sg13_hv_pmos ad=1.125p pd=5u as=1.125p ps=5u w=4.5u l=0.5u
X602 a_6650_4750# lpopamp_core_0.sliceB_0.bpa_l a_6550_4750# avdd sg13_hv_pmos ad=1.125p pd=5u as=1.125p ps=5u w=4.5u l=0.5u
X603 a_23750_7800# lpopamp_core_0.sliceB_1.zn_m lpopamp_core_0.sliceB_1.yn_p avss sg13_hv_nmos ad=1.125p pd=5u as=1.125p ps=5u w=4.5u l=0.5u
X604 a_19650_14850# lpopamp_core_0.sliceA_1.bna avss avss sg13_hv_nmos ad=1.125p pd=5u as=1.125p ps=5u w=4.5u l=3.5u
X605 a_20050_7800# lpopamp_core_0.sliceB_1.bnb a_20350_7800# avss sg13_hv_nmos ad=1.125p pd=5u as=1.125p ps=5u w=4.5u l=0.5u
X606 zn_p lpopamp_core_0.sliceB_0.zn_m a_25750_6550# avss sg13_hv_nmos ad=1.125p pd=5u as=1.125p ps=5u w=4.5u l=0.5u
X607 a_9750_6550# lpopamp_core_0.sliceB_0.bnb lpopamp_core_0.sliceB_0.bna_ avss sg13_hv_nmos ad=1.125p pd=5u as=1.125p ps=5u w=4.5u l=0.5u
X608 lpopamp_core_0.sliceB_0.bpb lpopamp_core_0.sliceB_0.bpb lpopamp_core_0.sliceB_0.bpa_l avdd sg13_hv_pmos ad=1.125p pd=5u as=1.125p ps=5u w=4.5u l=0.5u
X609 zp_p lpopamp_core_0.sliceB_0.zp_m lpopamp_core_0.sliceB_0.yp_m avdd sg13_hv_pmos ad=1.125p pd=5u as=1.125p ps=5u w=4.5u l=0.5u
X610 avss lpopamp_core_0.sliceB_1.zn_m a_28050_7800# avss sg13_hv_nmos ad=1.125p pd=5u as=1.125p ps=5u w=4.5u l=3.5u
X611 a_17250_700# lpopamp_core_0.sliceA_0.zn_m lpopamp_core_0.sliceA_0.yn_p avss sg13_hv_nmos ad=1.125p pd=5u as=1.125p ps=5u w=4.5u l=3.5u
X612 a_2850_14850# lpopamp_core_0.sliceA_1.bna avss avss sg13_hv_nmos ad=1.125p pd=5u as=1.125p ps=5u w=4.5u l=3.5u
X613 a_8550_11850# lpopamp_core_0.sliceA_1.bpa_l lpopamp_core_0.sliceA_1.bpa_l avdd sg13_hv_pmos ad=1.125p pd=5u as=1.125p ps=5u w=4.5u l=0.5u
X614 lpopamp_core_0.sliceB_0.yn_p lpopamp_core_0.sliceB_0.zn_m a_22450_6550# avss sg13_hv_nmos ad=1.125p pd=5u as=1.125p ps=5u w=4.5u l=3.5u
X615 lpopamp_core_0.sliceA_0.xp in_m lpopamp_core_0.sliceA_0.yn_p avdd sg13_hv_pmos ad=1.125p pd=5u as=1.125p ps=5u w=4.5u l=0.5u
X616 avdd lpopamp_core_0.sliceB_0.zp_m lpopamp_core_0.sliceB_0.yp_p avdd sg13_hv_pmos ad=1.125p pd=5u as=1.125p ps=5u w=4.5u l=3.5u
X617 lpopamp_core_0.sliceA_0.bna_ lpopamp_core_0.sliceA_0.bnb a_9950_100# avss sg13_hv_nmos ad=1.125p pd=5u as=1.125p ps=5u w=4.5u l=0.5u
X618 a_9050_10800# lpopamp_core_0.sliceB_1.bpa_r a_8950_10800# avdd sg13_hv_pmos ad=1.125p pd=5u as=1.125p ps=5u w=4.5u l=0.5u
X619 lpopamp_core_0.sliceB_0.yp_m lpopamp_core_0.sliceB_0.zp_m zp_p avdd sg13_hv_pmos ad=1.125p pd=5u as=1.125p ps=5u w=4.5u l=0.5u
X620 zn_p lpopamp_core_0.sliceA_0.zn_m a_26150_700# avss sg13_hv_nmos ad=1.125p pd=5u as=1.125p ps=5u w=4.5u l=0.5u
X621 a_25950_100# lpopamp_core_0.sliceA_0.zn_m zn_p avss sg13_hv_nmos ad=1.125p pd=5u as=1.125p ps=5u w=4.5u l=0.5u
X622 a_10950_8400# lpopamp_core_0.sliceB_1.bnb lpopamp_core_0.sliceB_1.bna_ avss sg13_hv_nmos ad=1.125p pd=5u as=1.125p ps=5u w=4.5u l=0.5u
X623 a_23550_14250# lpopamp_core_0.sliceA_1.zn_m lpopamp_core_0.sliceA_1.zn_m avss sg13_hv_nmos ad=1.125p pd=5u as=1.125p ps=5u w=4.5u l=0.5u
X624 a_11050_10200# lpopamp_core_0.sliceB_1.bpa_r a_10950_10200# avdd sg13_hv_pmos ad=1.125p pd=5u as=1.125p ps=5u w=4.5u l=0.5u
X625 a_12350_14250# lpopamp_core_0.sliceA_1.bna_ a_12250_14250# avss sg13_hv_nmos ad=1.125p pd=5u as=1.125p ps=5u w=4.5u l=0.5u
X626 zn_p lpopamp_core_0.sliceA_1.zn_m a_27350_14250# avss sg13_hv_nmos ad=1.125p pd=5u as=1.125p ps=5u w=4.5u l=0.5u
X627 zp_p lpopamp_core_0.sliceB_1.zp_m lpopamp_core_0.sliceB_1.yp_m avdd sg13_hv_pmos ad=1.125p pd=5u as=1.125p ps=5u w=4.5u l=0.5u
X628 zn_p lpopamp_core_0.sliceA_0.bpb zp_p avdd sg13_hv_pmos ad=1.125p pd=5u as=1.125p ps=5u w=4.5u l=0.5u
X629 lpopamp_core_0.sliceB_1.zp_m lpopamp_core_0.sliceB_1.zp_m lpopamp_core_0.sliceB_1.yp_p avdd sg13_hv_pmos ad=1.125p pd=5u as=1.125p ps=5u w=4.5u l=0.5u
X630 a_15650_8400# lpopamp_core_0.sliceB_1.bna lpopamp_core_0.sliceB_1.xn avss sg13_hv_nmos ad=1.125p pd=5u as=1.125p ps=5u w=4.5u l=3.5u
X631 lpopamp_core_0.sliceA_1.yp_p lpopamp_core_0.sliceA_1.zp_m lpopamp_core_0.sliceA_1.zp_m avdd sg13_hv_pmos ad=1.125p pd=5u as=1.125p ps=5u w=4.5u l=0.5u
X632 lpopamp_core_0.sliceA_0.zn_m lpopamp_core_0.sliceA_0.bpb a_23850_2500# avdd sg13_hv_pmos ad=1.125p pd=5u as=1.125p ps=5u w=4.5u l=0.5u
X633 lpopamp_core_0.sliceA_0.bpa_l lpopamp_core_0.sliceA_0.bpb lpopamp_core_0.sliceA_0.bpb avdd sg13_hv_pmos ad=1.125p pd=5u as=1.125p ps=5u w=4.5u l=0.5u
X634 lpopamp_core_0.sliceB_1.bna_ lpopamp_core_0.sliceB_1.bnb a_11950_8400# avss sg13_hv_nmos ad=1.125p pd=5u as=1.125p ps=5u w=4.5u l=0.5u
X635 a_7650_700# lpopamp_core_0.sliceA_0.bna lpopamp_core_0.sliceA_0.bpb avss sg13_hv_nmos ad=1.125p pd=5u as=1.125p ps=5u w=4.5u l=3.5u
X636 a_11350_700# lpopamp_core_0.sliceA_0.bnb lpopamp_core_0.sliceA_0.bna_ avss sg13_hv_nmos ad=1.125p pd=5u as=1.125p ps=5u w=4.5u l=0.5u
X637 out zp_p avdd avdd sg13_hv_pmos ad=1.125p pd=5u as=1.125p ps=5u w=4.5u l=0.5u
X638 ib en lpopamp_core_0.sliceA_1.bna avss sg13_hv_nmos ad=1.125p pd=5u as=1.125p ps=5u w=4.5u l=1.5u
X639 lpopamp_core_0.sliceA_1.xp lpopamp_core_0.sliceA_1.bpa avdd avdd sg13_hv_pmos ad=1.125p pd=5u as=1.125p ps=5u w=4.5u l=3.5u
X640 a_14150_7150# in_p lpopamp_core_0.sliceB_0.xn avss sg13_hv_nmos ad=1.125p pd=5u as=1.125p ps=5u w=4.5u l=0.5u
X641 lpopamp_core_0.sliceB_1.bna_ lpopamp_core_0.sliceB_1.bnb a_9550_8400# avss sg13_hv_nmos ad=1.125p pd=5u as=1.125p ps=5u w=4.5u l=0.5u
X642 zn_p lpopamp_core_0.sliceA_0.zn_m a_27350_100# avss sg13_hv_nmos ad=1.125p pd=5u as=1.125p ps=5u w=4.5u l=0.5u
X643 a_25750_8400# lpopamp_core_0.sliceB_1.zn_m lpopamp_core_0.sliceB_1.yn_m avss sg13_hv_nmos ad=1.125p pd=5u as=1.125p ps=5u w=4.5u l=0.5u
X644 avdd zp_p out avdd sg13_hv_pmos ad=1.125p pd=5u as=1.125p ps=5u w=4.5u l=0.5u
X645 a_20350_100# lpopamp_core_0.sliceA_0.bnb lpopamp_core_0.sliceA_0.zp_m avss sg13_hv_nmos ad=1.125p pd=5u as=1.125p ps=5u w=4.5u l=0.5u
X646 avss lpopamp_core_0.sliceA_1.bna a_21650_14850# avss sg13_hv_nmos ad=1.125p pd=5u as=1.125p ps=5u w=4.5u l=3.5u
X647 zp_p lpopamp_core_0.sliceA_1.bpb zn_p avdd sg13_hv_pmos ad=1.125p pd=5u as=1.125p ps=5u w=4.5u l=0.5u
X648 a_10550_14850# lpopamp_core_0.sliceA_1.bnb lpopamp_core_0.sliceA_1.bna_ avss sg13_hv_nmos ad=1.125p pd=5u as=1.125p ps=5u w=4.5u l=0.5u
X649 lpopamp_core_0.sliceA_1.yn_p in_m lpopamp_core_0.sliceA_1.xp avdd sg13_hv_pmos ad=1.125p pd=5u as=1.125p ps=5u w=4.5u l=0.5u
X650 lpopamp_core_0.sliceB_1.zn_m lpopamp_core_0.sliceB_1.bpb a_23850_10200# avdd sg13_hv_pmos ad=1.125p pd=5u as=1.125p ps=5u w=4.5u l=0.5u
X651 avss lpopamp_core_0.sliceB_0.zn_m a_24450_7150# avss sg13_hv_nmos ad=1.125p pd=5u as=1.125p ps=5u w=4.5u l=3.5u
X652 a_8450_7150# lpopamp_core_0.sliceB_0.bna_ a_8350_7150# avss sg13_hv_nmos ad=1.125p pd=5u as=1.125p ps=5u w=4.5u l=0.5u
X653 a_8750_12450# lpopamp_core_0.sliceA_1.bpa_l a_8650_12450# avdd sg13_hv_pmos ad=1.125p pd=5u as=1.125p ps=5u w=4.5u l=0.5u
X654 lpopamp_core_0.sliceA_1.xn in_m a_14350_14850# avss sg13_hv_nmos ad=1.125p pd=5u as=1.125p ps=5u w=4.5u l=0.5u
X655 a_13750_7800# in_p lpopamp_core_0.sliceB_1.xn avss sg13_hv_nmos ad=1.125p pd=5u as=1.125p ps=5u w=4.5u l=0.5u
X656 a_29550_14850# zn_p out avss sg13_hv_nmos ad=1.125p pd=5u as=1.125p ps=5u w=4.5u l=0.5u
X657 a_8550_100# lpopamp_core_0.sliceA_0.bna_ a_8450_100# avss sg13_hv_nmos ad=1.125p pd=5u as=1.125p ps=5u w=4.5u l=0.5u
X658 a_20050_6550# lpopamp_core_0.sliceB_0.bnb a_21150_7150# avss sg13_hv_nmos ad=1.125p pd=5u as=1.125p ps=5u w=4.5u l=0.5u
X659 lpopamp_core_0.sliceB_1.xp in_p lpopamp_core_0.sliceB_1.yn_m avdd sg13_hv_pmos ad=1.125p pd=5u as=1.125p ps=5u w=4.5u l=0.5u
X660 a_12550_100# lpopamp_core_0.sliceA_0.bna_ a_12450_100# avss sg13_hv_nmos ad=1.125p pd=5u as=1.125p ps=5u w=4.5u l=0.5u
X661 lpopamp_core_0.sliceB_0.yn_m in_p lpopamp_core_0.sliceB_0.xp avdd sg13_hv_pmos ad=1.125p pd=5u as=1.125p ps=5u w=4.5u l=0.5u
X662 lpopamp_core_0.sliceB_1.bna_ lpopamp_core_0.sliceB_1.bnb a_10350_7800# avss sg13_hv_nmos ad=1.125p pd=5u as=1.125p ps=5u w=4.5u l=0.5u
X663 a_28750_700# zn_p out avss sg13_hv_nmos ad=1.125p pd=5u as=1.125p ps=5u w=4.5u l=0.5u
X664 lpopamp_core_0.sliceB_0.yn_m in_p lpopamp_core_0.sliceB_0.xp avdd sg13_hv_pmos ad=1.125p pd=5u as=1.125p ps=5u w=4.5u l=0.5u
X665 lpopamp_core_0.sliceB_1.yn_p lpopamp_core_0.sliceB_1.zn_m a_18050_7800# avss sg13_hv_nmos ad=1.125p pd=5u as=1.125p ps=5u w=4.5u l=3.5u
X666 lpopamp_core_0.sliceA_1.bpb lpopamp_core_0.sliceA_1.bpb lpopamp_core_0.sliceA_1.bpa_l avdd sg13_hv_pmos ad=1.125p pd=5u as=1.125p ps=5u w=4.5u l=0.5u
X667 a_12550_6550# lpopamp_core_0.sliceB_0.bna_ a_12450_6550# avss sg13_hv_nmos ad=1.125p pd=5u as=1.125p ps=5u w=4.5u l=0.5u
X668 avdd zp_p out avdd sg13_hv_pmos ad=1.125p pd=5u as=1.125p ps=5u w=4.5u l=0.5u
X669 lpopamp_core_0.sliceB_0.bpb lpopamp_core_0.sliceB_0.bpb lpopamp_core_0.sliceB_0.bpa_r avdd sg13_hv_pmos ad=1.125p pd=5u as=1.125p ps=5u w=4.5u l=0.5u
X670 lpopamp_core_0.sliceA_0.tihi lpopamp_core_0.sliceA_0.tihi avdd avdd sg13_hv_pmos ad=1.125p pd=5u as=1.125p ps=5u w=4.5u l=9.5u
X671 lpopamp_core_0.sliceB_1.bpa_l lpopamp_core_0.sliceB_1.bpb lpopamp_core_0.sliceB_1.bpb avdd sg13_hv_pmos ad=1.125p pd=5u as=1.125p ps=5u w=4.5u l=0.5u
X672 avdd lpopamp_core_0.sliceA_0.zp_m lpopamp_core_0.sliceA_0.yp_m avdd sg13_hv_pmos ad=1.125p pd=5u as=1.125p ps=5u w=4.5u l=3.5u
X673 a_9350_14850# lpopamp_core_0.sliceA_1.bnb lpopamp_core_0.sliceA_1.bna_ avss sg13_hv_nmos ad=1.125p pd=5u as=1.125p ps=5u w=4.5u l=0.5u
X674 a_20050_7800# lpopamp_core_0.sliceB_1.bnb a_20750_7800# avss sg13_hv_nmos ad=1.125p pd=5u as=1.125p ps=5u w=4.5u l=0.5u
X675 avss lpopamp_core_0.sliceB_1.enb lpopamp_core_0.sliceB_1.bna avss sg13_hv_nmos ad=1.125p pd=5u as=1.125p ps=5u w=4.5u l=1.5u
X676 lpopamp_core_0.sliceB_1.yp_p lpopamp_core_0.sliceB_1.zp_m lpopamp_core_0.sliceB_1.zp_m avdd sg13_hv_pmos ad=1.125p pd=5u as=1.125p ps=5u w=4.5u l=0.5u
X677 lpopamp_core_0.sliceA_1.yn_p lpopamp_core_0.sliceA_1.zn_m a_22450_14250# avss sg13_hv_nmos ad=1.125p pd=5u as=1.125p ps=5u w=4.5u l=3.5u
X678 lpopamp_core_0.sliceA_0.bnb lpopamp_core_0.sliceA_0.bnb a_9750_700# avss sg13_hv_nmos ad=1.125p pd=5u as=1.125p ps=5u w=4.5u l=0.5u
X679 a_22450_2500# lpopamp_core_0.sliceA_0.bpb lpopamp_core_0.sliceA_0.zn_m avdd sg13_hv_pmos ad=1.125p pd=5u as=1.125p ps=5u w=4.5u l=0.5u
X680 zp_p lpopamp_core_0.sliceB_0.bpb zn_p avdd sg13_hv_pmos ad=1.125p pd=5u as=1.125p ps=5u w=4.5u l=0.5u
X681 a_28550_7800# zn_p avss avss sg13_hv_nmos ad=1.125p pd=5u as=1.125p ps=5u w=4.5u l=0.5u
X682 lpopamp_core_0.sliceB_1.bpa_r lpopamp_core_0.sliceB_1.bpb lpopamp_core_0.sliceB_1.bpb avdd sg13_hv_pmos ad=1.125p pd=5u as=1.125p ps=5u w=4.5u l=0.5u
X683 lpopamp_core_0.sliceB_0.bpb lpopamp_core_0.sliceB_0.bpb lpopamp_core_0.sliceB_0.bpa_l avdd sg13_hv_pmos ad=1.125p pd=5u as=1.125p ps=5u w=4.5u l=0.5u
X684 a_11350_14250# lpopamp_core_0.sliceA_1.bnb lpopamp_core_0.sliceA_1.bna_ avss sg13_hv_nmos ad=1.125p pd=5u as=1.125p ps=5u w=4.5u l=0.5u
X685 zp_p lpopamp_core_0.sliceA_1.bnb a_26350_14250# avss sg13_hv_nmos ad=1.125p pd=5u as=1.125p ps=5u w=4.5u l=0.5u
X686 lpopamp_core_0.sliceA_0.yp_p in_m a_13750_700# avss sg13_hv_nmos ad=1.125p pd=5u as=1.125p ps=5u w=4.5u l=0.5u
X687 a_22950_6550# lpopamp_core_0.sliceB_0.zn_m lpopamp_core_0.sliceB_0.yn_p avss sg13_hv_nmos ad=1.125p pd=5u as=1.125p ps=5u w=4.5u l=0.5u
X688 lpopamp_core_0.sliceA_1.xn in_p a_15150_14250# avss sg13_hv_nmos ad=1.125p pd=5u as=1.125p ps=5u w=4.5u l=0.5u
X689 avdd zp_p out avdd sg13_hv_pmos ad=1.125p pd=5u as=1.125p ps=5u w=4.5u l=0.5u
X690 lpopamp_core_0.sliceB_0.yp_p lpopamp_core_0.sliceB_0.zp_m avdd avdd sg13_hv_pmos ad=1.125p pd=5u as=1.125p ps=5u w=4.5u l=3.5u
X691 a_23850_4150# lpopamp_core_0.sliceB_0.bpb lpopamp_core_0.sliceB_0.zn_m avdd sg13_hv_pmos ad=1.125p pd=5u as=1.125p ps=5u w=4.5u l=0.5u
X692 lpopamp_core_0.sliceB_0.bpb lpopamp_core_0.sliceB_0.bpb lpopamp_core_0.sliceB_0.bpa_l avdd sg13_hv_pmos ad=1.125p pd=5u as=1.125p ps=5u w=4.5u l=0.5u
X693 avdd lpopamp_core_0.sliceB_1.bpa lpopamp_core_0.sliceB_1.xp avdd sg13_hv_pmos ad=1.125p pd=5u as=1.125p ps=5u w=4.5u l=3.5u
X694 a_9150_7800# lpopamp_core_0.sliceB_1.bnb lpopamp_core_0.sliceB_1.bnb avss sg13_hv_nmos ad=1.125p pd=5u as=1.125p ps=5u w=4.5u l=0.5u
X695 lpopamp_core_0.sliceA_0.xn in_m a_13950_100# avss sg13_hv_nmos ad=1.125p pd=5u as=1.125p ps=5u w=4.5u l=0.5u
X696 lpopamp_core_0.sliceB_0.bna en ib avss sg13_hv_nmos ad=1.125p pd=5u as=1.125p ps=5u w=4.5u l=1.5u
X697 a_29950_100# zn_p out avss sg13_hv_nmos ad=1.125p pd=5u as=1.125p ps=5u w=4.5u l=0.5u
X698 a_23150_700# lpopamp_core_0.sliceA_0.zn_m lpopamp_core_0.sliceA_0.zn_m avss sg13_hv_nmos ad=1.125p pd=5u as=1.125p ps=5u w=4.5u l=0.5u
X699 a_27350_6550# lpopamp_core_0.sliceB_0.zn_m lpopamp_core_0.sliceB_0.yn_m avss sg13_hv_nmos ad=1.125p pd=5u as=1.125p ps=5u w=4.5u l=0.5u
X700 a_9050_4150# lpopamp_core_0.sliceB_0.bpa_r a_8950_4150# avdd sg13_hv_pmos ad=1.125p pd=5u as=1.125p ps=5u w=4.5u l=0.5u
X701 zp_p lpopamp_core_0.sliceA_1.zp_m lpopamp_core_0.sliceA_1.yp_m avdd sg13_hv_pmos ad=1.125p pd=5u as=1.125p ps=5u w=4.5u l=0.5u
X702 a_11050_2500# lpopamp_core_0.sliceA_0.bpa_r a_10950_2500# avdd sg13_hv_pmos ad=1.125p pd=5u as=1.125p ps=5u w=4.5u l=0.5u
X703 lpopamp_core_0.sliceB_0.yn_p lpopamp_core_0.sliceB_0.zn_m a_23950_6550# avss sg13_hv_nmos ad=1.125p pd=5u as=1.125p ps=5u w=4.5u l=0.5u
X704 lpopamp_core_0.sliceA_1.yn_p in_m lpopamp_core_0.sliceA_1.xp avdd sg13_hv_pmos ad=1.125p pd=5u as=1.125p ps=5u w=4.5u l=0.5u
X705 avss en lpopamp_core_0.sliceA_1.enb avss sg13_hv_nmos ad=1.125p pd=5u as=1.125p ps=5u w=4.5u l=1.5u
X706 zp_p en avdd avdd sg13_hv_pmos ad=1.125p pd=5u as=1.125p ps=5u w=4.5u l=1.5u
X707 lpopamp_core_0.sliceB_1.bpb lpopamp_core_0.sliceB_1.bpb lpopamp_core_0.sliceB_1.bpa_r avdd sg13_hv_pmos ad=1.125p pd=5u as=1.125p ps=5u w=4.5u l=0.5u
X708 avss lpopamp_core_0.sliceB_1.bna a_15650_8400# avss sg13_hv_nmos ad=1.125p pd=5u as=1.125p ps=5u w=4.5u l=3.5u
X709 a_12450_8400# lpopamp_core_0.sliceB_1.bna_ a_12350_8400# avss sg13_hv_nmos ad=1.125p pd=5u as=1.125p ps=5u w=4.5u l=0.5u
X710 a_8650_2500# lpopamp_core_0.sliceA_0.bpa_l a_8550_2500# avdd sg13_hv_pmos ad=1.125p pd=5u as=1.125p ps=5u w=4.5u l=0.5u
X711 a_22450_11850# lpopamp_core_0.sliceA_1.bpb lpopamp_core_0.sliceA_1.zn_m avdd sg13_hv_pmos ad=1.125p pd=5u as=1.125p ps=5u w=4.5u l=0.5u
X712 a_15650_700# lpopamp_core_0.sliceA_0.bna lpopamp_core_0.sliceA_0.xn avss sg13_hv_nmos ad=1.125p pd=5u as=1.125p ps=5u w=4.5u l=3.5u
X713 a_20750_14850# lpopamp_core_0.sliceA_1.bnb lpopamp_core_0.sliceA_1.zp_m avss sg13_hv_nmos ad=1.125p pd=5u as=1.125p ps=5u w=4.5u l=0.5u
X714 lpopamp_core_0.sliceA_1.yp_m lpopamp_core_0.sliceA_1.zp_m avdd avdd sg13_hv_pmos ad=1.125p pd=5u as=1.125p ps=5u w=4.5u l=3.5u
X715 lpopamp_core_0.sliceA_0.yp_p lpopamp_core_0.sliceA_0.zp_m lpopamp_core_0.sliceA_0.zp_m avdd sg13_hv_pmos ad=1.125p pd=5u as=1.125p ps=5u w=4.5u l=0.5u
X716 avdd lpopamp_core_0.sliceA_0.bpa lpopamp_core_0.sliceA_0.bpa avdd sg13_hv_pmos ad=1.125p pd=5u as=1.125p ps=5u w=4.5u l=3.5u
X717 a_14550_7150# in_m lpopamp_core_0.sliceB_0.xn avss sg13_hv_nmos ad=1.125p pd=5u as=1.125p ps=5u w=4.5u l=0.5u
X718 lpopamp_core_0.sliceA_1.bpb lpopamp_core_0.sliceA_1.bpb lpopamp_core_0.sliceA_1.bpa_l avdd sg13_hv_pmos ad=1.125p pd=5u as=1.125p ps=5u w=4.5u l=0.5u
X719 out zp_p avdd avdd sg13_hv_pmos ad=1.125p pd=5u as=1.125p ps=5u w=4.5u l=0.5u
X720 lpopamp_core_0.sliceB_1.bnb lpopamp_core_0.sliceB_1.bpa avdd avdd sg13_hv_pmos ad=1.125p pd=5u as=1.125p ps=5u w=4.5u l=3.5u
X721 lpopamp_core_0.sliceB_1.yp_m lpopamp_core_0.sliceB_1.zp_m zp_p avdd sg13_hv_pmos ad=1.125p pd=5u as=1.125p ps=5u w=4.5u l=0.5u
X722 a_28550_14850# zn_p avss avss sg13_hv_nmos ad=1.125p pd=5u as=1.125p ps=5u w=4.5u l=0.5u
X723 lpopamp_core_0.sliceB_0.bna_ lpopamp_core_0.sliceB_0.bnb a_11150_7150# avss sg13_hv_nmos ad=1.125p pd=5u as=1.125p ps=5u w=4.5u l=0.5u
X724 avss lpopamp_core_0.sliceA_1.zn_m a_17250_14850# avss sg13_hv_nmos ad=1.125p pd=5u as=1.125p ps=5u w=4.5u l=3.5u
X725 a_25250_7150# lpopamp_core_0.sliceB_0.zn_m avss avss sg13_hv_nmos ad=1.125p pd=5u as=1.125p ps=5u w=4.5u l=3.5u
X726 a_6550_11850# lpopamp_core_0.sliceA_1.bpa_l avdd avdd sg13_hv_pmos ad=1.125p pd=5u as=1.125p ps=5u w=4.5u l=0.5u
X727 lpopamp_core_0.sliceB_0.bna_ lpopamp_core_0.sliceB_0.bna_ a_8750_7150# avss sg13_hv_nmos ad=1.125p pd=5u as=1.125p ps=5u w=4.5u l=0.5u
X728 lpopamp_core_0.sliceB_1.yn_m lpopamp_core_0.sliceB_1.zn_m a_27150_8400# avss sg13_hv_nmos ad=1.125p pd=5u as=1.125p ps=5u w=4.5u l=0.5u
X729 lpopamp_core_0.sliceB_1.bpa_l lpopamp_core_0.sliceB_1.bpb lpopamp_core_0.sliceB_1.bpb avdd sg13_hv_pmos ad=1.125p pd=5u as=1.125p ps=5u w=4.5u l=0.5u
X730 lpopamp_core_0.sliceA_0.yn_p lpopamp_core_0.sliceA_0.zn_m a_16450_100# avss sg13_hv_nmos ad=1.125p pd=5u as=1.125p ps=5u w=4.5u l=3.5u
X731 a_8350_14850# lpopamp_core_0.sliceA_1.bna_ a_8250_14850# avss sg13_hv_nmos ad=1.125p pd=5u as=1.125p ps=5u w=4.5u l=0.5u
X732 a_29350_7150# zn_p avss avss sg13_hv_nmos ad=1.125p pd=5u as=1.125p ps=5u w=4.5u l=0.5u
X733 lpopamp_core_0.sliceB_1.bna_ lpopamp_core_0.sliceB_1.bnb a_10750_7800# avss sg13_hv_nmos ad=1.125p pd=5u as=1.125p ps=5u w=4.5u l=0.5u
X734 lpopamp_core_0.sliceB_1.yp_p lpopamp_core_0.sliceB_1.zp_m lpopamp_core_0.sliceB_1.zp_m avdd sg13_hv_pmos ad=1.125p pd=5u as=1.125p ps=5u w=4.5u l=0.5u
X735 a_18850_7800# lpopamp_core_0.sliceB_1.zn_m lpopamp_core_0.sliceB_1.yn_p avss sg13_hv_nmos ad=1.125p pd=5u as=1.125p ps=5u w=4.5u l=3.5u
X736 a_10350_14250# lpopamp_core_0.sliceA_1.bnb lpopamp_core_0.sliceA_1.bnb avss sg13_hv_nmos ad=1.125p pd=5u as=1.125p ps=5u w=4.5u l=0.5u
X737 lpopamp_core_0.sliceB_1.zn_m lpopamp_core_0.sliceB_1.bpb a_23850_10200# avdd sg13_hv_pmos ad=1.125p pd=5u as=1.125p ps=5u w=4.5u l=0.5u
X738 lpopamp_core_0.sliceB_0.yn_m lpopamp_core_0.sliceB_0.zn_m a_25950_7150# avss sg13_hv_nmos ad=1.125p pd=5u as=1.125p ps=5u w=4.5u l=0.5u
X739 a_13250_6550# lpopamp_core_0.sliceB_0.bna avss avss sg13_hv_nmos ad=1.125p pd=5u as=1.125p ps=5u w=4.5u l=3.5u
X740 lpopamp_core_0.sliceA_1.yp_p in_m a_14150_14250# avss sg13_hv_nmos ad=1.125p pd=5u as=1.125p ps=5u w=4.5u l=0.5u
X741 lpopamp_core_0.sliceB_1.yp_m lpopamp_core_0.sliceB_1.zp_m zp_p avdd sg13_hv_pmos ad=1.125p pd=5u as=1.125p ps=5u w=4.5u l=0.5u
X742 lpopamp_core_0.sliceB_0.bpb lpopamp_core_0.sliceB_0.bpb lpopamp_core_0.sliceB_0.bpa_r avdd sg13_hv_pmos ad=1.125p pd=5u as=1.125p ps=5u w=4.5u l=0.5u
X743 lpopamp_core_0.sliceB_1.xn in_m a_15150_7800# avss sg13_hv_nmos ad=1.125p pd=5u as=1.125p ps=5u w=4.5u l=0.5u
X744 a_29350_14250# zn_p avss avss sg13_hv_nmos ad=1.125p pd=5u as=1.125p ps=5u w=4.5u l=0.5u
X745 lpopamp_core_0.sliceA_1.yn_m lpopamp_core_0.sliceA_1.zn_m a_18050_14250# avss sg13_hv_nmos ad=1.125p pd=5u as=1.125p ps=5u w=4.5u l=3.5u
X746 lpopamp_core_0.sliceA_0.yp_m lpopamp_core_0.sliceA_0.zp_m avdd avdd sg13_hv_pmos ad=1.125p pd=5u as=1.125p ps=5u w=4.5u l=3.5u
X747 lpopamp_core_0.sliceB_0.xp in_m lpopamp_core_0.sliceB_0.yn_p avdd sg13_hv_pmos ad=1.125p pd=5u as=1.125p ps=5u w=4.5u l=0.5u
X748 avss lpopamp_core_0.sliceB_0.zn_m a_17250_6550# avss sg13_hv_nmos ad=1.125p pd=5u as=1.125p ps=5u w=4.5u l=3.5u
X749 zp_p lpopamp_core_0.sliceB_0.zp_m lpopamp_core_0.sliceB_0.yp_m avdd sg13_hv_pmos ad=1.125p pd=5u as=1.125p ps=5u w=4.5u l=0.5u
X750 lpopamp_core_0.sliceA_0.bpb lpopamp_core_0.sliceA_0.bpb lpopamp_core_0.sliceA_0.bpa_l avdd sg13_hv_pmos ad=1.125p pd=5u as=1.125p ps=5u w=4.5u l=0.5u
X751 lpopamp_core_0.sliceB_0.xn in_p a_13950_6550# avss sg13_hv_nmos ad=1.125p pd=5u as=1.125p ps=5u w=4.5u l=0.5u
X752 a_28950_7800# zn_p avss avss sg13_hv_nmos ad=1.125p pd=5u as=1.125p ps=5u w=4.5u l=0.5u
X753 avdd lpopamp_core_0.sliceA_1.bpa lpopamp_core_0.sliceA_1.yp_m avdd sg13_hv_pmos ad=1.125p pd=5u as=1.125p ps=5u w=4.5u l=3.5u
X754 a_10750_700# lpopamp_core_0.sliceA_0.bnb lpopamp_core_0.sliceA_0.bnb avss sg13_hv_nmos ad=1.125p pd=5u as=1.125p ps=5u w=4.5u l=0.5u
X755 lpopamp_core_0.sliceA_0.zp_m lpopamp_core_0.sliceA_0.zp_m lpopamp_core_0.sliceA_0.yp_p avdd sg13_hv_pmos ad=1.125p pd=5u as=1.125p ps=5u w=4.5u l=0.5u
X756 a_8550_4750# lpopamp_core_0.sliceB_0.bpa_l lpopamp_core_0.sliceB_0.bpa_l avdd sg13_hv_pmos ad=1.125p pd=5u as=1.125p ps=5u w=4.5u l=0.5u
X757 a_9550_7800# lpopamp_core_0.sliceB_1.bnb lpopamp_core_0.sliceB_1.bnb avss sg13_hv_nmos ad=1.125p pd=5u as=1.125p ps=5u w=4.5u l=0.5u
X758 a_8950_10200# lpopamp_core_0.sliceB_1.bpa_r avdd avdd sg13_hv_pmos ad=1.125p pd=5u as=1.125p ps=5u w=4.5u l=0.5u
X759 avdd zp_p out avdd sg13_hv_pmos ad=1.125p pd=5u as=1.125p ps=5u w=4.5u l=0.5u
X760 a_9150_14250# lpopamp_core_0.sliceA_1.bnb lpopamp_core_0.sliceA_1.bnb avss sg13_hv_nmos ad=1.125p pd=5u as=1.125p ps=5u w=4.5u l=0.5u
X761 lpopamp_core_0.sliceB_0.zp_m lpopamp_core_0.sliceB_0.zp_m lpopamp_core_0.sliceB_0.yp_p avdd sg13_hv_pmos ad=1.125p pd=5u as=1.125p ps=5u w=4.5u l=0.5u
X762 a_27150_700# lpopamp_core_0.sliceA_0.zn_m zn_p avss sg13_hv_nmos ad=1.125p pd=5u as=1.125p ps=5u w=4.5u l=0.5u
X763 zp_p lpopamp_core_0.sliceA_0.bnb a_26750_100# avss sg13_hv_nmos ad=1.125p pd=5u as=1.125p ps=5u w=4.5u l=0.5u
X764 a_28050_6550# lpopamp_core_0.sliceB_0.zn_m lpopamp_core_0.sliceB_0.yn_m avss sg13_hv_nmos ad=1.125p pd=5u as=1.125p ps=5u w=4.5u l=3.5u
X765 lpopamp_core_0.sliceA_1.bpa_r lpopamp_core_0.sliceA_1.bpb lpopamp_core_0.sliceA_1.bpb avdd sg13_hv_pmos ad=1.125p pd=5u as=1.125p ps=5u w=4.5u l=0.5u
X766 zp_p lpopamp_core_0.sliceB_0.zp_m lpopamp_core_0.sliceB_0.yp_m avdd sg13_hv_pmos ad=1.125p pd=5u as=1.125p ps=5u w=4.5u l=0.5u
X767 avdd zp_p out avdd sg13_hv_pmos ad=1.125p pd=5u as=1.125p ps=5u w=4.5u l=0.5u
X768 zp_p lpopamp_core_0.sliceA_1.bpb zn_p avdd sg13_hv_pmos ad=1.125p pd=5u as=1.125p ps=5u w=4.5u l=0.5u
X769 lpopamp_core_0.sliceB_0.bpa_r lpopamp_core_0.sliceB_0.bpb lpopamp_core_0.sliceB_0.bpb avdd sg13_hv_pmos ad=1.125p pd=5u as=1.125p ps=5u w=4.5u l=0.5u
X770 a_8350_6550# lpopamp_core_0.sliceB_0.bna_ a_8250_6550# avss sg13_hv_nmos ad=1.125p pd=5u as=1.125p ps=5u w=4.5u l=0.5u
X771 a_6750_12450# lpopamp_core_0.sliceA_1.bpa_l a_6650_12450# avdd sg13_hv_pmos ad=1.125p pd=5u as=1.125p ps=5u w=4.5u l=0.5u
X772 lpopamp_core_0.sliceA_1.yp_m lpopamp_core_0.sliceA_1.zp_m avdd avdd sg13_hv_pmos ad=1.125p pd=5u as=1.125p ps=5u w=4.5u l=3.5u
X773 lpopamp_core_0.sliceA_1.yn_p lpopamp_core_0.sliceA_1.zn_m a_23550_14850# avss sg13_hv_nmos ad=1.125p pd=5u as=1.125p ps=5u w=4.5u l=0.5u
X774 avdd zp_p out avdd sg13_hv_pmos ad=1.125p pd=5u as=1.125p ps=5u w=4.5u l=0.5u
X775 avdd lpopamp_core_0.sliceB_0.bpa lpopamp_core_0.sliceB_0.bpa avdd sg13_hv_pmos ad=1.125p pd=5u as=1.125p ps=5u w=4.5u l=3.5u
X776 a_11150_10800# lpopamp_core_0.sliceB_1.bpa_r a_11050_10800# avdd sg13_hv_pmos ad=1.125p pd=5u as=1.125p ps=5u w=4.5u l=0.5u
X777 a_12450_14850# lpopamp_core_0.sliceA_1.bna_ a_12350_14850# avss sg13_hv_nmos ad=1.125p pd=5u as=1.125p ps=5u w=4.5u l=0.5u
X778 lpopamp_core_0.sliceA_1.xp in_p lpopamp_core_0.sliceA_1.yn_m avdd sg13_hv_pmos ad=1.125p pd=5u as=1.125p ps=5u w=4.5u l=0.5u
X779 lpopamp_core_0.sliceB_1.yp_m lpopamp_core_0.sliceB_1.zp_m zp_p avdd sg13_hv_pmos ad=1.125p pd=5u as=1.125p ps=5u w=4.5u l=0.5u
X780 a_21150_6550# lpopamp_core_0.sliceB_0.bnb lpopamp_core_0.sliceB_0.zp_m avss sg13_hv_nmos ad=1.125p pd=5u as=1.125p ps=5u w=4.5u l=0.5u
X781 a_27550_14850# lpopamp_core_0.sliceA_1.zn_m zn_p avss sg13_hv_nmos ad=1.125p pd=5u as=1.125p ps=5u w=4.5u l=0.5u
X782 avss lpopamp_core_0.sliceB_1.bna_ a_12750_8400# avss sg13_hv_nmos ad=1.125p pd=5u as=1.125p ps=5u w=4.5u l=0.5u
X783 a_8250_700# lpopamp_core_0.sliceA_0.bna_ a_8150_700# avss sg13_hv_nmos ad=1.125p pd=5u as=1.125p ps=5u w=4.5u l=0.5u
X784 a_19650_700# lpopamp_core_0.sliceA_0.bna avss avss sg13_hv_nmos ad=1.125p pd=5u as=1.125p ps=5u w=4.5u l=3.5u
X785 a_12250_700# lpopamp_core_0.sliceA_0.bna_ a_12150_700# avss sg13_hv_nmos ad=1.125p pd=5u as=1.125p ps=5u w=4.5u l=0.5u
X786 a_11950_100# lpopamp_core_0.sliceA_0.bnb lpopamp_core_0.sliceA_0.bnb avss sg13_hv_nmos ad=1.125p pd=5u as=1.125p ps=5u w=4.5u l=0.5u
X787 lpopamp_core_0.sliceA_0.bpa lpopamp_core_0.sliceA_0.bpa avdd avdd sg13_hv_pmos ad=1.125p pd=5u as=1.125p ps=5u w=4.5u l=3.5u
X788 a_14950_7150# in_m lpopamp_core_0.sliceB_0.xn avss sg13_hv_nmos ad=1.125p pd=5u as=1.125p ps=5u w=4.5u l=0.5u
X789 out zp_p avdd avdd sg13_hv_pmos ad=1.125p pd=5u as=1.125p ps=5u w=4.5u l=0.5u
X790 lpopamp_core_0.sliceB_1.enb en avdd avdd sg13_hv_pmos ad=1.125p pd=5u as=2.25p ps=10u w=4.5u l=1.5u
X791 lpopamp_core_0.sliceA_1.bpa_r lpopamp_core_0.sliceA_1.bpb lpopamp_core_0.sliceA_1.bpb avdd sg13_hv_pmos ad=1.125p pd=5u as=1.125p ps=5u w=4.5u l=0.5u
X792 lpopamp_core_0.sliceB_0.bna_ lpopamp_core_0.sliceB_0.bnb a_11550_7150# avss sg13_hv_nmos ad=1.125p pd=5u as=1.125p ps=5u w=4.5u l=0.5u
X793 lpopamp_core_0.sliceA_0.yp_m lpopamp_core_0.sliceA_0.zp_m zp_p avdd sg13_hv_pmos ad=1.125p pd=5u as=1.125p ps=5u w=4.5u l=0.5u
X794 a_20050_100# lpopamp_core_0.sliceA_0.bnb a_21150_100# avss sg13_hv_nmos ad=1.125p pd=5u as=1.125p ps=5u w=4.5u l=0.5u
X795 a_7650_14850# lpopamp_core_0.sliceA_1.bna lpopamp_core_0.sliceA_1.bpb avss sg13_hv_nmos ad=1.125p pd=5u as=1.125p ps=5u w=4.5u l=3.5u
X796 a_19650_7150# lpopamp_core_0.sliceB_0.bna avss avss sg13_hv_nmos ad=1.125p pd=5u as=1.125p ps=5u w=4.5u l=3.5u
X797 avss lpopamp_core_0.sliceA_0.enb zn_p avss sg13_hv_nmos ad=2.25p pd=10u as=1.125p ps=5u w=4.5u l=1.5u
X798 a_20550_14250# lpopamp_core_0.sliceA_1.bnb a_20050_14250# avss sg13_hv_nmos ad=1.125p pd=5u as=1.125p ps=5u w=4.5u l=0.5u
X799 avdd lpopamp_core_0.sliceB_1.bpa a_22450_10200# avdd sg13_hv_pmos ad=1.125p pd=5u as=1.125p ps=5u w=4.5u l=3.5u
X800 lpopamp_core_0.sliceB_1.yn_m lpopamp_core_0.sliceB_1.zn_m a_27550_8400# avss sg13_hv_nmos ad=1.125p pd=5u as=1.125p ps=5u w=4.5u l=0.5u
X801 lpopamp_core_0.sliceB_1.yn_m in_p lpopamp_core_0.sliceB_1.xp avdd sg13_hv_pmos ad=1.125p pd=5u as=1.125p ps=5u w=4.5u l=0.5u
X802 lpopamp_core_0.sliceA_0.bnb lpopamp_core_0.sliceA_0.bnb a_9350_100# avss sg13_hv_nmos ad=1.125p pd=5u as=1.125p ps=5u w=4.5u l=0.5u
X803 avss en lpopamp_core_0.sliceA_0.enb avss sg13_hv_nmos ad=1.125p pd=5u as=1.125p ps=5u w=4.5u l=1.5u
X804 lpopamp_core_0.sliceA_0.yn_p in_m lpopamp_core_0.sliceA_0.xp avdd sg13_hv_pmos ad=1.125p pd=5u as=1.125p ps=5u w=4.5u l=0.5u
X805 a_8250_8400# lpopamp_core_0.sliceB_1.bna_ a_8150_8400# avss sg13_hv_nmos ad=1.125p pd=5u as=1.125p ps=5u w=4.5u l=0.5u
X806 a_29750_7150# zn_p avss avss sg13_hv_nmos ad=1.125p pd=5u as=1.125p ps=5u w=4.5u l=0.5u
X807 lpopamp_core_0.sliceA_1.bpa_r lpopamp_core_0.sliceA_1.bpb lpopamp_core_0.sliceA_1.bpb avdd sg13_hv_pmos ad=1.125p pd=5u as=1.125p ps=5u w=4.5u l=0.5u
X808 lpopamp_core_0.sliceB_1.zp_m lpopamp_core_0.sliceB_1.bnb a_20950_8400# avss sg13_hv_nmos ad=1.125p pd=5u as=1.125p ps=5u w=4.5u l=0.5u
X809 lpopamp_core_0.sliceA_0.yn_p lpopamp_core_0.sliceA_0.zn_m a_22450_700# avss sg13_hv_nmos ad=1.125p pd=5u as=1.125p ps=5u w=4.5u l=3.5u
X810 avss zn_p a_29550_700# avss sg13_hv_nmos ad=1.125p pd=5u as=1.125p ps=5u w=4.5u l=0.5u
X811 zp_p lpopamp_core_0.sliceA_1.bpb zn_p avdd sg13_hv_pmos ad=1.125p pd=5u as=1.125p ps=5u w=4.5u l=0.5u
X812 zp_p lpopamp_core_0.sliceB_0.bnb a_26350_7150# avss sg13_hv_nmos ad=1.125p pd=5u as=1.125p ps=5u w=4.5u l=0.5u
X813 avss lpopamp_core_0.sliceB_1.zn_m a_18850_7800# avss sg13_hv_nmos ad=1.125p pd=5u as=1.125p ps=5u w=4.5u l=3.5u
X814 avdd zp_p out avdd sg13_hv_pmos ad=1.125p pd=5u as=1.125p ps=5u w=4.5u l=0.5u
X815 avdd zp_p out avdd sg13_hv_pmos ad=1.125p pd=5u as=1.125p ps=5u w=4.5u l=0.5u
X816 lpopamp_core_0.sliceA_0.bpb lpopamp_core_0.sliceA_0.bpb lpopamp_core_0.sliceA_0.bpa_r avdd sg13_hv_pmos ad=1.125p pd=5u as=1.125p ps=5u w=4.5u l=0.5u
X817 lpopamp_core_0.sliceA_1.xp in_p lpopamp_core_0.sliceA_1.yn_m avdd sg13_hv_pmos ad=1.125p pd=5u as=1.125p ps=5u w=4.5u l=0.5u
X818 a_23150_7150# lpopamp_core_0.sliceB_0.zn_m lpopamp_core_0.sliceB_0.zn_m avss sg13_hv_nmos ad=1.125p pd=5u as=1.125p ps=5u w=4.5u l=0.5u
X819 lpopamp_core_0.sliceB_1.bpb lpopamp_core_0.sliceB_1.bpb lpopamp_core_0.sliceB_1.bpa_l avdd sg13_hv_pmos ad=1.125p pd=5u as=1.125p ps=5u w=4.5u l=0.5u
X820 lpopamp_core_0.sliceB_0.xp in_m lpopamp_core_0.sliceB_0.yn_p avdd sg13_hv_pmos ad=1.125p pd=5u as=1.125p ps=5u w=4.5u l=0.5u
X821 a_8150_14250# lpopamp_core_0.sliceA_1.bna_ avss avss sg13_hv_nmos ad=1.125p pd=5u as=1.125p ps=5u w=4.5u l=0.5u
X822 lpopamp_core_0.sliceB_0.bnb lpopamp_core_0.sliceB_0.bpa avdd avdd sg13_hv_pmos ad=1.125p pd=5u as=1.125p ps=5u w=4.5u l=3.5u
X823 a_12350_7800# lpopamp_core_0.sliceB_1.bna_ a_12250_7800# avss sg13_hv_nmos ad=1.125p pd=5u as=1.125p ps=5u w=4.5u l=0.5u
X824 a_18050_6550# lpopamp_core_0.sliceB_0.zn_m avss avss sg13_hv_nmos ad=1.125p pd=5u as=1.125p ps=5u w=4.5u l=3.5u
X825 lpopamp_core_0.sliceA_0.bpb lpopamp_core_0.sliceA_0.bpb lpopamp_core_0.sliceA_0.bpa_l avdd sg13_hv_pmos ad=1.125p pd=5u as=1.125p ps=5u w=4.5u l=0.5u
X826 lpopamp_core_0.sliceB_0.xn in_p a_14350_6550# avss sg13_hv_nmos ad=1.125p pd=5u as=1.125p ps=5u w=4.5u l=0.5u
X827 lpopamp_core_0.sliceA_1.bpa lpopamp_core_0.sliceA_1.bpa avdd avdd sg13_hv_pmos ad=1.125p pd=5u as=1.125p ps=5u w=4.5u l=3.5u
X828 lpopamp_core_0.sliceB_1.zp_m lpopamp_core_0.sliceB_1.zp_m lpopamp_core_0.sliceB_1.yp_p avdd sg13_hv_pmos ad=1.125p pd=5u as=1.125p ps=5u w=4.5u l=0.5u
X829 a_14750_700# in_p lpopamp_core_0.sliceA_0.yp_m avss sg13_hv_nmos ad=1.125p pd=5u as=1.125p ps=5u w=4.5u l=0.5u
X830 a_28650_11850# zp_p out avdd sg13_hv_pmos ad=1.125p pd=5u as=1.125p ps=5u w=4.5u l=0.5u
X831 lpopamp_core_0.sliceB_1.bpb lpopamp_core_0.sliceB_1.bpb lpopamp_core_0.sliceB_1.bpa_r avdd sg13_hv_pmos ad=1.125p pd=5u as=1.125p ps=5u w=4.5u l=0.5u
X832 a_8950_4750# lpopamp_core_0.sliceB_0.bpa_r avdd avdd sg13_hv_pmos ad=1.125p pd=5u as=1.125p ps=5u w=4.5u l=0.5u
X833 a_9950_7800# lpopamp_core_0.sliceB_1.bnb lpopamp_core_0.sliceB_1.bnb avss sg13_hv_nmos ad=1.125p pd=5u as=1.125p ps=5u w=4.5u l=0.5u
X834 lpopamp_core_0.sliceA_1.bnb lpopamp_core_0.sliceA_1.bnb a_11350_14850# avss sg13_hv_nmos ad=1.125p pd=5u as=1.125p ps=5u w=4.5u l=0.5u
X835 lpopamp_core_0.sliceA_1.bpa_r lpopamp_core_0.sliceA_1.bpb lpopamp_core_0.sliceA_1.bpb avdd sg13_hv_pmos ad=1.125p pd=5u as=1.125p ps=5u w=4.5u l=0.5u
X836 a_11150_6550# lpopamp_core_0.sliceB_0.bnb lpopamp_core_0.sliceB_0.bnb avss sg13_hv_nmos ad=1.125p pd=5u as=1.125p ps=5u w=4.5u l=0.5u
X837 a_26550_14850# lpopamp_core_0.sliceA_1.bnb zp_p avss sg13_hv_nmos ad=1.125p pd=5u as=1.125p ps=5u w=4.5u l=0.5u
X838 a_15650_14850# lpopamp_core_0.sliceA_1.bna lpopamp_core_0.sliceA_1.xn avss sg13_hv_nmos ad=1.125p pd=5u as=1.125p ps=5u w=4.5u l=3.5u
X839 out zp_p a_29050_10800# avdd sg13_hv_pmos ad=1.125p pd=5u as=1.125p ps=5u w=4.5u l=0.5u
X840 avdd lpopamp_core_0.sliceB_0.zp_m lpopamp_core_0.sliceB_0.yp_p avdd sg13_hv_pmos ad=1.125p pd=5u as=1.125p ps=5u w=4.5u l=3.5u
X841 lpopamp_core_0.sliceA_0.yn_p lpopamp_core_0.sliceA_0.zn_m a_23950_700# avss sg13_hv_nmos ad=1.125p pd=5u as=1.125p ps=5u w=4.5u l=0.5u
X842 a_23750_100# lpopamp_core_0.sliceA_0.zn_m lpopamp_core_0.sliceA_0.yn_p avss sg13_hv_nmos ad=1.125p pd=5u as=1.125p ps=5u w=4.5u l=0.5u
X843 avdd zp_p out avdd sg13_hv_pmos ad=1.125p pd=5u as=1.125p ps=5u w=4.5u l=0.5u
X844 zp_p lpopamp_core_0.sliceB_0.bpb zn_p avdd sg13_hv_pmos ad=1.125p pd=5u as=1.125p ps=5u w=4.5u l=0.5u
X845 lpopamp_core_0.sliceB_0.bpa_r lpopamp_core_0.sliceB_0.bpb lpopamp_core_0.sliceB_0.bpb avdd sg13_hv_pmos ad=1.125p pd=5u as=1.125p ps=5u w=4.5u l=0.5u
X846 avdd en lpopamp_core_0.sliceB_0.enb avdd sg13_hv_pmos ad=1.125p pd=5u as=1.125p ps=5u w=4.5u l=1.5u
X847 ib en lpopamp_core_0.sliceB_1.bna avss sg13_hv_nmos ad=1.125p pd=5u as=1.125p ps=5u w=4.5u l=1.5u
X848 a_8750_6550# lpopamp_core_0.sliceB_0.bna_ a_8650_6550# avss sg13_hv_nmos ad=1.125p pd=5u as=1.125p ps=5u w=4.5u l=0.5u
X849 lpopamp_core_0.sliceA_1.bpa en avdd avdd sg13_hv_pmos ad=1.125p pd=5u as=1.125p ps=5u w=4.5u l=1.5u
X850 a_22450_4150# lpopamp_core_0.sliceB_0.bpb lpopamp_core_0.sliceB_0.zn_m avdd sg13_hv_pmos ad=1.125p pd=5u as=1.125p ps=5u w=4.5u l=0.5u
X851 zp_p lpopamp_core_0.sliceB_0.zp_m lpopamp_core_0.sliceB_0.yp_m avdd sg13_hv_pmos ad=1.125p pd=5u as=1.125p ps=5u w=4.5u l=0.5u
X852 a_27150_7800# lpopamp_core_0.sliceB_1.zn_m zn_p avss sg13_hv_nmos ad=1.125p pd=5u as=1.125p ps=5u w=4.5u l=0.5u
X853 a_6550_4150# lpopamp_core_0.sliceB_0.bpa_l avdd avdd sg13_hv_pmos ad=1.125p pd=5u as=1.125p ps=5u w=4.5u l=0.5u
X854 lpopamp_core_0.sliceA_1.bpa_l lpopamp_core_0.sliceA_1.bpb lpopamp_core_0.sliceA_1.bpb avdd sg13_hv_pmos ad=1.125p pd=5u as=1.125p ps=5u w=4.5u l=0.5u
X855 avss zn_p a_29150_6550# avss sg13_hv_nmos ad=1.125p pd=5u as=1.125p ps=5u w=4.5u l=0.5u
X856 lpopamp_core_0.sliceB_0.enb en avss avss sg13_hv_nmos ad=1.125p pd=5u as=2.25p ps=10u w=4.5u l=1.5u
X857 a_22450_10200# lpopamp_core_0.sliceB_1.bpa avdd avdd sg13_hv_pmos ad=1.125p pd=5u as=1.125p ps=5u w=4.5u l=3.5u
X858 lpopamp_core_0.sliceA_1.zn_m lpopamp_core_0.sliceA_1.zn_m a_23350_14250# avss sg13_hv_nmos ad=1.125p pd=5u as=1.125p ps=5u w=4.5u l=0.5u
X859 out zp_p avdd avdd sg13_hv_pmos ad=1.125p pd=5u as=1.125p ps=5u w=4.5u l=0.5u
X860 a_12250_14250# lpopamp_core_0.sliceA_1.bna_ a_12150_14250# avss sg13_hv_nmos ad=1.125p pd=5u as=1.125p ps=5u w=4.5u l=0.5u
X861 lpopamp_core_0.sliceB_1.yp_m lpopamp_core_0.sliceB_1.zp_m zp_p avdd sg13_hv_pmos ad=1.125p pd=5u as=1.125p ps=5u w=4.5u l=0.5u
X862 a_27350_14250# lpopamp_core_0.sliceA_1.zn_m lpopamp_core_0.sliceA_1.yn_m avss sg13_hv_nmos ad=1.125p pd=5u as=1.125p ps=5u w=4.5u l=0.5u
X863 a_16450_14250# lpopamp_core_0.sliceA_1.zn_m avss avss sg13_hv_nmos ad=1.125p pd=5u as=1.125p ps=5u w=4.5u l=3.5u
X864 lpopamp_core_0.sliceB_1.yp_p lpopamp_core_0.sliceB_1.zp_m lpopamp_core_0.sliceB_1.zp_m avdd sg13_hv_pmos ad=1.125p pd=5u as=1.125p ps=5u w=4.5u l=0.5u
X865 a_14350_8400# in_p lpopamp_core_0.sliceB_1.yp_m avss sg13_hv_nmos ad=1.125p pd=5u as=1.125p ps=5u w=4.5u l=0.5u
X866 a_20050_6550# lpopamp_core_0.sliceB_0.bna a_19650_7150# avss sg13_hv_nmos ad=1.125p pd=5u as=1.125p ps=5u w=4.5u l=3.5u
X867 lpopamp_core_0.sliceB_1.bnb lpopamp_core_0.sliceB_1.bnb a_10950_8400# avss sg13_hv_nmos ad=1.125p pd=5u as=1.125p ps=5u w=4.5u l=0.5u
X868 lpopamp_core_0.sliceA_0.bpa_l lpopamp_core_0.sliceA_0.bpb lpopamp_core_0.sliceA_0.bpb avdd sg13_hv_pmos ad=1.125p pd=5u as=1.125p ps=5u w=4.5u l=0.5u
X869 lpopamp_core_0.sliceA_1.yp_m lpopamp_core_0.sliceA_1.zp_m avdd avdd sg13_hv_pmos ad=1.125p pd=5u as=1.125p ps=5u w=4.5u l=3.5u
X870 lpopamp_core_0.sliceA_1.yp_p lpopamp_core_0.sliceA_1.zp_m avdd avdd sg13_hv_pmos ad=1.125p pd=5u as=1.125p ps=5u w=4.5u l=3.5u
X871 avdd zp_p out avdd sg13_hv_pmos ad=1.125p pd=5u as=1.125p ps=5u w=4.5u l=0.5u
X872 lpopamp_core_0.sliceA_0.yp_p lpopamp_core_0.sliceA_0.zp_m lpopamp_core_0.sliceA_0.zp_m avdd sg13_hv_pmos ad=1.125p pd=5u as=1.125p ps=5u w=4.5u l=0.5u
X873 lpopamp_core_0.sliceB_1.bpb lpopamp_core_0.sliceB_1.bpb lpopamp_core_0.sliceB_1.bpa_l avdd sg13_hv_pmos ad=1.125p pd=5u as=1.125p ps=5u w=4.5u l=0.5u
X874 a_8650_8400# lpopamp_core_0.sliceB_1.bna_ a_8550_8400# avss sg13_hv_nmos ad=1.125p pd=5u as=1.125p ps=5u w=4.5u l=0.5u
X875 a_10350_100# lpopamp_core_0.sliceA_0.bnb lpopamp_core_0.sliceA_0.bnb avss sg13_hv_nmos ad=1.125p pd=5u as=1.125p ps=5u w=4.5u l=0.5u
X876 lpopamp_core_0.sliceB_1.bpa lpopamp_core_0.sliceB_1.bna a_5250_8400# avss sg13_hv_nmos ad=1.125p pd=5u as=1.125p ps=5u w=4.5u l=3.5u
X877 a_26550_700# lpopamp_core_0.sliceA_0.bnb zp_p avss sg13_hv_nmos ad=1.125p pd=5u as=1.125p ps=5u w=4.5u l=0.5u
X878 zp_p lpopamp_core_0.sliceB_0.bnb a_26750_7150# avss sg13_hv_nmos ad=1.125p pd=5u as=1.125p ps=5u w=4.5u l=0.5u
X879 avdd en lpopamp_core_0.sliceA_1.bpa avdd sg13_hv_pmos ad=1.125p pd=5u as=1.125p ps=5u w=4.5u l=1.5u
X880 avdd lpopamp_core_0.sliceA_1.bpa lpopamp_core_0.sliceA_1.bnb avdd sg13_hv_pmos ad=1.125p pd=5u as=1.125p ps=5u w=4.5u l=3.5u
X881 avdd lpopamp_core_0.sliceB_1.zp_m lpopamp_core_0.sliceB_1.yp_p avdd sg13_hv_pmos ad=1.125p pd=5u as=1.125p ps=5u w=4.5u l=3.5u
X882 a_29150_8400# zn_p out avss sg13_hv_nmos ad=1.125p pd=5u as=1.125p ps=5u w=4.5u l=0.5u
X883 zn_p lpopamp_core_0.sliceA_1.bpb zp_p avdd sg13_hv_pmos ad=1.125p pd=5u as=1.125p ps=5u w=4.5u l=0.5u
X884 lpopamp_core_0.sliceA_0.bpb lpopamp_core_0.sliceA_0.bpb lpopamp_core_0.sliceA_0.bpa_r avdd sg13_hv_pmos ad=1.125p pd=5u as=1.125p ps=5u w=4.5u l=0.5u
X885 a_23550_7150# lpopamp_core_0.sliceB_0.zn_m lpopamp_core_0.sliceB_0.zn_m avss sg13_hv_nmos ad=1.125p pd=5u as=1.125p ps=5u w=4.5u l=0.5u
X886 lpopamp_core_0.sliceA_1.bna_ lpopamp_core_0.sliceA_1.bnb a_10350_14850# avss sg13_hv_nmos ad=1.125p pd=5u as=1.125p ps=5u w=4.5u l=0.5u
X887 a_8650_12450# lpopamp_core_0.sliceA_1.bpa_l a_8550_12450# avdd sg13_hv_pmos ad=1.125p pd=5u as=1.125p ps=5u w=4.5u l=0.5u
X888 a_23850_10200# lpopamp_core_0.sliceB_1.bpb lpopamp_core_0.sliceB_1.zn_m avdd sg13_hv_pmos ad=1.125p pd=5u as=1.125p ps=5u w=4.5u l=0.5u
X889 lpopamp_core_0.sliceA_0.xp in_p lpopamp_core_0.sliceA_0.yn_m avdd sg13_hv_pmos ad=1.125p pd=5u as=1.125p ps=5u w=4.5u l=0.5u
X890 a_14350_14850# in_m lpopamp_core_0.sliceA_1.yp_p avss sg13_hv_nmos ad=1.125p pd=5u as=1.125p ps=5u w=4.5u l=0.5u
X891 avdd lpopamp_core_0.sliceB_1.zp_m lpopamp_core_0.sliceB_1.yp_m avdd sg13_hv_pmos ad=1.125p pd=5u as=1.125p ps=5u w=4.5u l=3.5u
X892 avdd lpopamp_core_0.sliceB_0.bpa lpopamp_core_0.sliceB_0.bnb avdd sg13_hv_pmos ad=1.125p pd=5u as=1.125p ps=5u w=4.5u l=3.5u
X893 out zn_p a_29350_14850# avss sg13_hv_nmos ad=1.125p pd=5u as=1.125p ps=5u w=4.5u l=0.5u
X894 lpopamp_core_0.sliceB_0.zp_m lpopamp_core_0.sliceB_0.bnb a_20150_7150# avss sg13_hv_nmos ad=1.125p pd=5u as=1.125p ps=5u w=4.5u l=0.5u
X895 avss lpopamp_core_0.sliceB_0.bna a_4050_7150# avss sg13_hv_nmos ad=1.125p pd=5u as=1.125p ps=5u w=4.5u l=3.5u
X896 a_12750_7800# lpopamp_core_0.sliceB_1.bna_ a_12650_7800# avss sg13_hv_nmos ad=1.125p pd=5u as=1.125p ps=5u w=4.5u l=0.5u
X897 lpopamp_core_0.sliceB_0.xn in_m a_14750_6550# avss sg13_hv_nmos ad=1.125p pd=5u as=1.125p ps=5u w=4.5u l=0.5u
X898 lpopamp_core_0.sliceA_0.bna_ lpopamp_core_0.sliceA_0.bnb a_11550_700# avss sg13_hv_nmos ad=1.125p pd=5u as=1.125p ps=5u w=4.5u l=0.5u
X899 avdd lpopamp_core_0.sliceA_1.tihi lpopamp_core_0.sliceA_1.tihi avdd sg13_hv_pmos ad=1.125p pd=5u as=1.125p ps=5u w=4.5u l=9.5u
X900 lpopamp_core_0.sliceB_0.xp lpopamp_core_0.sliceB_0.bpa avdd avdd sg13_hv_pmos ad=1.125p pd=5u as=1.125p ps=5u w=4.5u l=3.5u
X901 a_11550_6550# lpopamp_core_0.sliceB_0.bnb lpopamp_core_0.sliceB_0.bnb avss sg13_hv_nmos ad=1.125p pd=5u as=1.125p ps=5u w=4.5u l=0.5u
X902 lpopamp_core_0.sliceA_1.bpa_l lpopamp_core_0.sliceA_1.bpb lpopamp_core_0.sliceA_1.bpb avdd sg13_hv_pmos ad=1.125p pd=5u as=1.125p ps=5u w=4.5u l=0.5u
X903 a_28650_3100# zp_p out avdd sg13_hv_pmos ad=1.125p pd=5u as=1.125p ps=5u w=4.5u l=0.5u
X904 lpopamp_core_0.sliceA_1.bpa lpopamp_core_0.sliceA_1.bna a_5250_14850# avss sg13_hv_nmos ad=1.125p pd=5u as=1.125p ps=5u w=4.5u l=3.5u
X905 a_28050_100# lpopamp_core_0.sliceA_0.zn_m lpopamp_core_0.sliceA_0.yn_m avss sg13_hv_nmos ad=1.125p pd=5u as=1.125p ps=5u w=4.5u l=3.5u
X906 lpopamp_core_0.sliceA_0.zp_m lpopamp_core_0.sliceA_0.bnb a_20550_100# avss sg13_hv_nmos ad=1.125p pd=5u as=1.125p ps=5u w=4.5u l=0.5u
X907 zp_p lpopamp_core_0.sliceA_0.zp_m lpopamp_core_0.sliceA_0.yp_m avdd sg13_hv_pmos ad=1.125p pd=5u as=1.125p ps=5u w=4.5u l=0.5u
X908 lpopamp_core_0.sliceB_0.xp in_p lpopamp_core_0.sliceB_0.yn_m avdd sg13_hv_pmos ad=1.125p pd=5u as=1.125p ps=5u w=4.5u l=0.5u
X909 lpopamp_core_0.sliceA_1.bna_ lpopamp_core_0.sliceA_1.bnb a_9150_14850# avss sg13_hv_nmos ad=1.125p pd=5u as=1.125p ps=5u w=4.5u l=0.5u
X910 lpopamp_core_0.sliceA_0.bpa_r lpopamp_core_0.sliceA_0.bpa_r a_9150_3100# avdd sg13_hv_pmos ad=1.125p pd=5u as=1.125p ps=5u w=4.5u l=0.5u
X911 avdd zp_p out avdd sg13_hv_pmos ad=1.125p pd=5u as=1.125p ps=5u w=4.5u l=0.5u
X912 a_4050_7800# lpopamp_core_0.sliceB_1.bna lpopamp_core_0.sliceB_1.bna avss sg13_hv_nmos ad=1.125p pd=5u as=1.125p ps=5u w=4.5u l=3.5u
X913 lpopamp_core_0.sliceB_1.zp_m lpopamp_core_0.sliceB_1.zp_m lpopamp_core_0.sliceB_1.yp_p avdd sg13_hv_pmos ad=1.125p pd=5u as=1.125p ps=5u w=4.5u l=0.5u
X914 lpopamp_core_0.sliceA_0.zp_m lpopamp_core_0.sliceA_0.zp_m lpopamp_core_0.sliceA_0.yp_p avdd sg13_hv_pmos ad=1.125p pd=5u as=1.125p ps=5u w=4.5u l=0.5u
X915 lpopamp_core_0.sliceB_0.bpb lpopamp_core_0.sliceB_0.bpb lpopamp_core_0.sliceB_0.bpa_l avdd sg13_hv_pmos ad=1.125p pd=5u as=1.125p ps=5u w=4.5u l=0.5u
X916 a_27550_7800# lpopamp_core_0.sliceB_1.zn_m zn_p avss sg13_hv_nmos ad=1.125p pd=5u as=1.125p ps=5u w=4.5u l=0.5u
X917 lpopamp_core_0.sliceA_1.bna_ lpopamp_core_0.sliceA_1.bnb a_11150_14250# avss sg13_hv_nmos ad=1.125p pd=5u as=1.125p ps=5u w=4.5u l=0.5u
X918 avdd lpopamp_core_0.sliceB_1.zp_m lpopamp_core_0.sliceB_1.yp_p avdd sg13_hv_pmos ad=1.125p pd=5u as=1.125p ps=5u w=4.5u l=3.5u
X919 a_26350_14250# lpopamp_core_0.sliceA_1.bnb zn_p avss sg13_hv_nmos ad=1.125p pd=5u as=1.125p ps=5u w=4.5u l=0.5u
X920 a_15150_14250# in_p lpopamp_core_0.sliceA_1.yp_m avss sg13_hv_nmos ad=1.125p pd=5u as=1.125p ps=5u w=4.5u l=0.5u
X921 lpopamp_core_0.sliceA_0.xp in_m lpopamp_core_0.sliceA_0.yn_p avdd sg13_hv_pmos ad=1.125p pd=5u as=1.125p ps=5u w=4.5u l=0.5u
X922 lpopamp_core_0.sliceB_1.xp in_m lpopamp_core_0.sliceB_1.yn_p avdd sg13_hv_pmos ad=1.125p pd=5u as=1.125p ps=5u w=4.5u l=0.5u
X923 lpopamp_core_0.sliceB_0.bpb lpopamp_core_0.sliceB_0.bpb lpopamp_core_0.sliceB_0.bpa_l avdd sg13_hv_pmos ad=1.125p pd=5u as=1.125p ps=5u w=4.5u l=0.5u
X924 avss zn_p a_29550_6550# avss sg13_hv_nmos ad=1.125p pd=5u as=1.125p ps=5u w=4.5u l=0.5u
X925 a_8150_7800# lpopamp_core_0.sliceB_1.bna_ avss avss sg13_hv_nmos ad=1.125p pd=5u as=1.125p ps=5u w=4.5u l=0.5u
X926 zp_p en avdd avdd sg13_hv_pmos ad=1.125p pd=5u as=1.125p ps=5u w=4.5u l=1.5u
X927 a_9150_700# lpopamp_core_0.sliceA_0.bnb lpopamp_core_0.sliceA_0.bnb avss sg13_hv_nmos ad=1.125p pd=5u as=1.125p ps=5u w=4.5u l=0.5u
X928 lpopamp_core_0.sliceA_0.bna_ lpopamp_core_0.sliceA_0.bna_ a_8750_100# avss sg13_hv_nmos ad=1.125p pd=5u as=1.125p ps=5u w=4.5u l=0.5u
X929 zn_p lpopamp_core_0.sliceB_0.bpb zp_p avdd sg13_hv_pmos ad=1.125p pd=5u as=1.125p ps=5u w=4.5u l=0.5u
X930 a_2850_6550# lpopamp_core_0.sliceB_0.bna avss avss sg13_hv_nmos ad=1.125p pd=5u as=1.125p ps=5u w=4.5u l=3.5u
X931 avdd lpopamp_core_0.sliceA_0.zp_m lpopamp_core_0.sliceA_0.yp_p avdd sg13_hv_pmos ad=1.125p pd=5u as=1.125p ps=5u w=4.5u l=3.5u
X932 lpopamp_core_0.sliceA_1.zn_m lpopamp_core_0.sliceA_1.bpb a_23850_11850# avdd sg13_hv_pmos ad=1.125p pd=5u as=1.125p ps=5u w=4.5u l=0.5u
X933 avss lpopamp_core_0.sliceA_0.bna_ a_12750_100# avss sg13_hv_nmos ad=1.125p pd=5u as=1.125p ps=5u w=4.5u l=0.5u
X934 a_26350_6550# lpopamp_core_0.sliceB_0.bnb zn_p avss sg13_hv_nmos ad=1.125p pd=5u as=1.125p ps=5u w=4.5u l=0.5u
X935 lpopamp_core_0.sliceB_0.zn_m lpopamp_core_0.sliceB_0.bpb a_23850_4150# avdd sg13_hv_pmos ad=1.125p pd=5u as=1.125p ps=5u w=4.5u l=0.5u
X936 lpopamp_core_0.sliceB_0.bpa_l lpopamp_core_0.sliceB_0.bpb lpopamp_core_0.sliceB_0.bpb avdd sg13_hv_pmos ad=1.125p pd=5u as=1.125p ps=5u w=4.5u l=0.5u
X937 lpopamp_core_0.sliceA_1.yp_m lpopamp_core_0.sliceA_1.zp_m zp_p avdd sg13_hv_pmos ad=1.125p pd=5u as=1.125p ps=5u w=4.5u l=0.5u
X938 lpopamp_core_0.sliceA_0.bpa_r lpopamp_core_0.sliceA_0.bpb lpopamp_core_0.sliceA_0.bpb avdd sg13_hv_pmos ad=1.125p pd=5u as=1.125p ps=5u w=4.5u l=0.5u
X939 lpopamp_core_0.sliceB_0.zn_m lpopamp_core_0.sliceB_0.zn_m a_22950_6550# avss sg13_hv_nmos ad=1.125p pd=5u as=1.125p ps=5u w=4.5u l=0.5u
X940 lpopamp_core_0.sliceA_1.xp in_m lpopamp_core_0.sliceA_1.yn_p avdd sg13_hv_pmos ad=1.125p pd=5u as=1.125p ps=5u w=4.5u l=0.5u
X941 avss zn_p a_29150_100# avss sg13_hv_nmos ad=1.125p pd=5u as=1.125p ps=5u w=4.5u l=0.5u
X942 a_22450_100# lpopamp_core_0.sliceA_0.zn_m avss avss sg13_hv_nmos ad=1.125p pd=5u as=1.125p ps=5u w=4.5u l=3.5u
X943 avss lpopamp_core_0.sliceA_1.bna a_6050_14250# avss sg13_hv_nmos ad=1.125p pd=5u as=1.125p ps=5u w=4.5u l=3.5u
X944 lpopamp_core_0.sliceB_1.bpa_r lpopamp_core_0.sliceB_1.bpb lpopamp_core_0.sliceB_1.bpb avdd sg13_hv_pmos ad=1.125p pd=5u as=1.125p ps=5u w=4.5u l=0.5u
X945 a_14750_8400# in_m lpopamp_core_0.sliceB_1.yp_p avss sg13_hv_nmos ad=1.125p pd=5u as=1.125p ps=5u w=4.5u l=0.5u
X946 avdd en zp_p avdd sg13_hv_pmos ad=2.25p pd=10u as=1.125p ps=5u w=4.5u l=1.5u
X947 lpopamp_core_0.sliceA_0.bpa_l lpopamp_core_0.sliceA_0.bpb lpopamp_core_0.sliceA_0.bpb avdd sg13_hv_pmos ad=1.125p pd=5u as=1.125p ps=5u w=4.5u l=0.5u
X948 lpopamp_core_0.sliceA_1.zn_m lpopamp_core_0.sliceA_1.bpb a_22450_11850# avdd sg13_hv_pmos ad=1.125p pd=5u as=1.125p ps=5u w=4.5u l=0.5u
X949 lpopamp_core_0.sliceB_1.bnb lpopamp_core_0.sliceB_1.bnb a_11350_8400# avss sg13_hv_nmos ad=1.125p pd=5u as=1.125p ps=5u w=4.5u l=0.5u
X950 lpopamp_core_0.sliceA_1.zp_m lpopamp_core_0.sliceA_1.bnb a_20550_14850# avss sg13_hv_nmos ad=1.125p pd=5u as=1.125p ps=5u w=4.5u l=0.5u
X951 avss lpopamp_core_0.sliceA_1.zn_m a_24450_14850# avss sg13_hv_nmos ad=1.125p pd=5u as=1.125p ps=5u w=4.5u l=3.5u
X952 lpopamp_core_0.sliceA_1.bpa_l lpopamp_core_0.sliceA_1.bpb lpopamp_core_0.sliceA_1.bpb avdd sg13_hv_pmos ad=1.125p pd=5u as=1.125p ps=5u w=4.5u l=0.5u
X953 avdd lpopamp_core_0.sliceA_0.zp_m lpopamp_core_0.sliceA_0.yp_m avdd sg13_hv_pmos ad=1.125p pd=5u as=1.125p ps=5u w=4.5u l=3.5u
X954 lpopamp_core_0.sliceA_1.xn lpopamp_core_0.sliceA_1.bna a_13250_14850# avss sg13_hv_nmos ad=1.125p pd=5u as=1.125p ps=5u w=4.5u l=3.5u
X955 lpopamp_core_0.sliceA_1.yp_p lpopamp_core_0.sliceA_1.zp_m avdd avdd sg13_hv_pmos ad=1.125p pd=5u as=1.125p ps=5u w=4.5u l=3.5u
X956 zp_p lpopamp_core_0.sliceB_1.zp_m lpopamp_core_0.sliceB_1.yp_m avdd sg13_hv_pmos ad=1.125p pd=5u as=1.125p ps=5u w=4.5u l=0.5u
X957 zn_p lpopamp_core_0.sliceB_0.enb avss avss sg13_hv_nmos ad=1.125p pd=5u as=1.125p ps=5u w=4.5u l=1.5u
X958 a_14350_100# in_m lpopamp_core_0.sliceA_0.yp_p avss sg13_hv_nmos ad=1.125p pd=5u as=1.125p ps=5u w=4.5u l=0.5u
X959 lpopamp_core_0.sliceB_0.bnb lpopamp_core_0.sliceB_0.bnb a_10150_7150# avss sg13_hv_nmos ad=1.125p pd=5u as=1.125p ps=5u w=4.5u l=0.5u
X960 lpopamp_core_0.sliceA_0.zn_m lpopamp_core_0.sliceA_0.zn_m a_23350_700# avss sg13_hv_nmos ad=1.125p pd=5u as=1.125p ps=5u w=4.5u l=0.5u
X961 a_6050_8400# lpopamp_core_0.sliceB_1.bna lpopamp_core_0.sliceB_1.bpa avss sg13_hv_nmos ad=1.125p pd=5u as=1.125p ps=5u w=4.5u l=3.5u
X962 lpopamp_core_0.sliceA_1.tihi lpopamp_core_0.sliceA_1.tihi avdd avdd sg13_hv_pmos ad=1.125p pd=5u as=1.125p ps=5u w=4.5u l=9.5u
X963 a_29550_8400# zn_p out avss sg13_hv_nmos ad=1.125p pd=5u as=1.125p ps=5u w=4.5u l=0.5u
X964 a_10950_3100# lpopamp_core_0.sliceA_0.bpa_r lpopamp_core_0.sliceA_0.bpa_r avdd sg13_hv_pmos ad=1.125p pd=5u as=1.125p ps=5u w=4.5u l=0.5u
X965 a_23950_7150# lpopamp_core_0.sliceB_0.zn_m lpopamp_core_0.sliceB_0.zn_m avss sg13_hv_nmos ad=1.125p pd=5u as=1.125p ps=5u w=4.5u l=0.5u
X966 lpopamp_core_0.sliceA_0.xp in_p lpopamp_core_0.sliceA_0.yn_m avdd sg13_hv_pmos ad=1.125p pd=5u as=1.125p ps=5u w=4.5u l=0.5u
X967 zn_p lpopamp_core_0.sliceB_1.zn_m a_26150_8400# avss sg13_hv_nmos ad=1.125p pd=5u as=1.125p ps=5u w=4.5u l=0.5u
X968 lpopamp_core_0.sliceB_0.zp_m lpopamp_core_0.sliceB_0.bnb a_20550_7150# avss sg13_hv_nmos ad=1.125p pd=5u as=1.125p ps=5u w=4.5u l=0.5u
X969 lpopamp_core_0.sliceB_0.bna lpopamp_core_0.sliceB_0.enb avss avss sg13_hv_nmos ad=1.125p pd=5u as=1.125p ps=5u w=4.5u l=1.5u
X970 lpopamp_core_0.sliceA_0.yp_m lpopamp_core_0.sliceA_0.zp_m avdd avdd sg13_hv_pmos ad=1.125p pd=5u as=1.125p ps=5u w=4.5u l=3.5u
X971 lpopamp_core_0.sliceB_0.yp_p lpopamp_core_0.sliceB_0.zp_m lpopamp_core_0.sliceB_0.zp_m avdd sg13_hv_pmos ad=1.125p pd=5u as=1.125p ps=5u w=4.5u l=0.5u
X972 a_8250_14850# lpopamp_core_0.sliceA_1.bna_ a_8150_14850# avss sg13_hv_nmos ad=1.125p pd=5u as=1.125p ps=5u w=4.5u l=0.5u
X973 lpopamp_core_0.sliceA_0.bna lpopamp_core_0.sliceA_0.enb avss avss sg13_hv_nmos ad=1.125p pd=5u as=1.125p ps=5u w=4.5u l=1.5u
X974 lpopamp_core_0.sliceB_1.zp_m lpopamp_core_0.sliceB_1.zp_m lpopamp_core_0.sliceB_1.yp_p avdd sg13_hv_pmos ad=1.125p pd=5u as=1.125p ps=5u w=4.5u l=0.5u
X975 lpopamp_core_0.sliceB_0.yn_m in_p lpopamp_core_0.sliceB_0.xp avdd sg13_hv_pmos ad=1.125p pd=5u as=1.125p ps=5u w=4.5u l=0.5u
X976 lpopamp_core_0.sliceA_1.bnb lpopamp_core_0.sliceA_1.bnb a_10150_14250# avss sg13_hv_nmos ad=1.125p pd=5u as=1.125p ps=5u w=4.5u l=0.5u
X977 a_23850_10200# lpopamp_core_0.sliceB_1.bpb lpopamp_core_0.sliceB_1.zn_m avdd sg13_hv_pmos ad=1.125p pd=5u as=1.125p ps=5u w=4.5u l=0.5u
X978 a_11950_6550# lpopamp_core_0.sliceB_0.bnb lpopamp_core_0.sliceB_0.bnb avss sg13_hv_nmos ad=1.125p pd=5u as=1.125p ps=5u w=4.5u l=0.5u
X979 lpopamp_core_0.sliceA_1.yn_m lpopamp_core_0.sliceA_1.zn_m a_25250_14250# avss sg13_hv_nmos ad=1.125p pd=5u as=1.125p ps=5u w=4.5u l=3.5u
X980 a_14150_14250# in_m lpopamp_core_0.sliceA_1.xn avss sg13_hv_nmos ad=1.125p pd=5u as=1.125p ps=5u w=4.5u l=0.5u
X981 lpopamp_core_0.sliceB_1.yp_m in_p a_14150_7800# avss sg13_hv_nmos ad=1.125p pd=5u as=1.125p ps=5u w=4.5u l=0.5u
X982 avss zn_p a_29150_14250# avss sg13_hv_nmos ad=1.125p pd=5u as=1.125p ps=5u w=4.5u l=0.5u
X983 zp_p lpopamp_core_0.sliceA_0.bpb zn_p avdd sg13_hv_pmos ad=1.125p pd=5u as=1.125p ps=5u w=4.5u l=0.5u
X984 lpopamp_core_0.sliceA_0.bpa_r lpopamp_core_0.sliceA_0.bpb lpopamp_core_0.sliceA_0.bpb avdd sg13_hv_pmos ad=1.125p pd=5u as=1.125p ps=5u w=4.5u l=0.5u
X985 lpopamp_core_0.sliceA_1.zn_m lpopamp_core_0.sliceA_1.bpb a_22450_11850# avdd sg13_hv_pmos ad=1.125p pd=5u as=1.125p ps=5u w=4.5u l=0.5u
X986 avdd lpopamp_core_0.sliceA_1.bpa lpopamp_core_0.sliceA_1.bnb avdd sg13_hv_pmos ad=1.125p pd=5u as=1.125p ps=5u w=4.5u l=3.5u
X987 avdd lpopamp_core_0.sliceB_0.zp_m lpopamp_core_0.sliceB_0.yp_m avdd sg13_hv_pmos ad=1.125p pd=5u as=1.125p ps=5u w=4.5u l=3.5u
X988 avss zn_p a_29950_8400# avss sg13_hv_nmos ad=1.125p pd=5u as=1.125p ps=5u w=4.5u l=0.5u
X989 lpopamp_core_0.sliceB_1.bpa lpopamp_core_0.sliceB_1.bpa avdd avdd sg13_hv_pmos ad=1.125p pd=5u as=1.125p ps=5u w=4.5u l=3.5u
X990 lpopamp_core_0.sliceB_0.bpb lpopamp_core_0.sliceB_0.bpb lpopamp_core_0.sliceB_0.bpa_l avdd sg13_hv_pmos ad=1.125p pd=5u as=1.125p ps=5u w=4.5u l=0.5u
X991 a_8550_7800# lpopamp_core_0.sliceB_1.bna_ a_8450_7800# avss sg13_hv_nmos ad=1.125p pd=5u as=1.125p ps=5u w=4.5u l=0.5u
X992 avdd lpopamp_core_0.sliceB_1.bpa_l a_8750_10200# avdd sg13_hv_pmos ad=1.125p pd=5u as=1.125p ps=5u w=4.5u l=0.5u
X993 lpopamp_core_0.sliceB_0.bna lpopamp_core_0.sliceB_0.bna a_2850_6550# avss sg13_hv_nmos ad=1.125p pd=5u as=1.125p ps=5u w=4.5u l=3.5u
X994 lpopamp_core_0.sliceA_1.bnb lpopamp_core_0.sliceA_1.bnb a_8950_14250# avss sg13_hv_nmos ad=1.125p pd=5u as=1.125p ps=5u w=4.5u l=0.5u
X995 a_6050_100# lpopamp_core_0.sliceA_0.bna lpopamp_core_0.sliceA_0.bpa avss sg13_hv_nmos ad=1.125p pd=5u as=1.125p ps=5u w=4.5u l=3.5u
X996 lpopamp_core_0.sliceA_0.yp_p lpopamp_core_0.sliceA_0.zp_m avdd avdd sg13_hv_pmos ad=1.125p pd=5u as=1.125p ps=5u w=4.5u l=3.5u
X997 lpopamp_core_0.sliceB_0.yp_m lpopamp_core_0.sliceB_0.zp_m zp_p avdd sg13_hv_pmos ad=1.125p pd=5u as=1.125p ps=5u w=4.5u l=0.5u
X998 avdd lpopamp_core_0.sliceB_0.zp_m lpopamp_core_0.sliceB_0.yp_p avdd sg13_hv_pmos ad=1.125p pd=5u as=1.125p ps=5u w=4.5u l=3.5u
X999 a_26750_6550# lpopamp_core_0.sliceB_0.bnb zn_p avss sg13_hv_nmos ad=1.125p pd=5u as=1.125p ps=5u w=4.5u l=0.5u
X1000 a_21650_7800# lpopamp_core_0.sliceB_1.bna a_20050_7800# avss sg13_hv_nmos ad=1.125p pd=5u as=1.125p ps=5u w=4.5u l=3.5u
X1001 avdd lpopamp_core_0.sliceA_1.zp_m lpopamp_core_0.sliceA_1.yp_p avdd sg13_hv_pmos ad=1.125p pd=5u as=1.125p ps=5u w=4.5u l=3.5u
X1002 lpopamp_core_0.sliceA_0.bna_ lpopamp_core_0.sliceA_0.bnb a_9950_700# avss sg13_hv_nmos ad=1.125p pd=5u as=1.125p ps=5u w=4.5u l=0.5u
X1003 avdd lpopamp_core_0.sliceB_0.bpa a_23850_4150# avdd sg13_hv_pmos ad=1.125p pd=5u as=1.125p ps=5u w=4.5u l=3.5u
X1004 lpopamp_core_0.sliceB_0.yp_m lpopamp_core_0.sliceB_0.zp_m zp_p avdd sg13_hv_pmos ad=1.125p pd=5u as=1.125p ps=5u w=4.5u l=0.5u
X1005 out zn_p a_28950_7800# avss sg13_hv_nmos ad=1.125p pd=5u as=1.125p ps=5u w=4.5u l=0.5u
X1006 lpopamp_core_0.sliceA_1.bpb lpopamp_core_0.sliceA_1.bpb lpopamp_core_0.sliceA_1.bpa_r avdd sg13_hv_pmos ad=1.125p pd=5u as=1.125p ps=5u w=4.5u l=0.5u
X1007 a_25950_700# lpopamp_core_0.sliceA_0.zn_m zn_p avss sg13_hv_nmos ad=1.125p pd=5u as=1.125p ps=5u w=4.5u l=0.5u
X1008 lpopamp_core_0.sliceA_0.bpa_r lpopamp_core_0.sliceA_0.bpb lpopamp_core_0.sliceA_0.bpb avdd sg13_hv_pmos ad=1.125p pd=5u as=1.125p ps=5u w=4.5u l=0.5u
X1009 lpopamp_core_0.sliceB_0.bpa_l lpopamp_core_0.sliceB_0.bpb lpopamp_core_0.sliceB_0.bpb avdd sg13_hv_pmos ad=1.125p pd=5u as=1.125p ps=5u w=4.5u l=0.5u
X1010 zn_p lpopamp_core_0.sliceA_1.bpb zp_p avdd sg13_hv_pmos ad=1.125p pd=5u as=1.125p ps=5u w=4.5u l=0.5u
X1011 lpopamp_core_0.sliceB_0.zn_m lpopamp_core_0.sliceB_0.zn_m a_23350_6550# avss sg13_hv_nmos ad=1.125p pd=5u as=1.125p ps=5u w=4.5u l=0.5u
X1012 a_7650_6550# lpopamp_core_0.sliceB_0.bna lpopamp_core_0.sliceB_0.bpb avss sg13_hv_nmos ad=1.125p pd=5u as=1.125p ps=5u w=4.5u l=3.5u
X1013 a_23550_14850# lpopamp_core_0.sliceA_1.zn_m lpopamp_core_0.sliceA_1.zn_m avss sg13_hv_nmos ad=1.125p pd=5u as=1.125p ps=5u w=4.5u l=0.5u
X1014 a_6650_12450# lpopamp_core_0.sliceA_1.bpa_l a_6550_12450# avdd sg13_hv_pmos ad=1.125p pd=5u as=1.125p ps=5u w=4.5u l=0.5u
X1015 out zp_p a_29450_11850# avdd sg13_hv_pmos ad=1.125p pd=5u as=1.125p ps=5u w=4.5u l=0.5u
X1016 lpopamp_core_0.sliceA_0.yn_m in_p lpopamp_core_0.sliceA_0.xp avdd sg13_hv_pmos ad=1.125p pd=5u as=1.125p ps=5u w=4.5u l=0.5u
X1017 lpopamp_core_0.sliceB_0.yp_p lpopamp_core_0.sliceB_0.zp_m lpopamp_core_0.sliceB_0.zp_m avdd sg13_hv_pmos ad=1.125p pd=5u as=1.125p ps=5u w=4.5u l=0.5u
X1018 a_11050_10800# lpopamp_core_0.sliceB_1.bpa_r a_10950_10800# avdd sg13_hv_pmos ad=1.125p pd=5u as=1.125p ps=5u w=4.5u l=0.5u
X1019 a_26150_100# lpopamp_core_0.sliceA_0.zn_m lpopamp_core_0.sliceA_0.yn_m avss sg13_hv_nmos ad=1.125p pd=5u as=1.125p ps=5u w=4.5u l=0.5u
X1020 a_12350_14850# lpopamp_core_0.sliceA_1.bna_ a_12250_14850# avss sg13_hv_nmos ad=1.125p pd=5u as=1.125p ps=5u w=4.5u l=0.5u
X1021 lpopamp_core_0.sliceA_1.yn_m in_p lpopamp_core_0.sliceA_1.xp avdd sg13_hv_pmos ad=1.125p pd=5u as=1.125p ps=5u w=4.5u l=0.5u
X1022 zp_p lpopamp_core_0.sliceB_1.zp_m lpopamp_core_0.sliceB_1.yp_m avdd sg13_hv_pmos ad=1.125p pd=5u as=1.125p ps=5u w=4.5u l=0.5u
X1023 a_20150_6550# lpopamp_core_0.sliceB_0.bnb a_20050_6550# avss sg13_hv_nmos ad=1.125p pd=5u as=1.125p ps=5u w=4.5u l=0.5u
X1024 zn_p lpopamp_core_0.sliceA_1.zn_m a_27350_14850# avss sg13_hv_nmos ad=1.125p pd=5u as=1.125p ps=5u w=4.5u l=0.5u
X1025 lpopamp_core_0.sliceB_1.zp_m lpopamp_core_0.sliceB_1.zp_m lpopamp_core_0.sliceB_1.yp_p avdd sg13_hv_pmos ad=1.125p pd=5u as=1.125p ps=5u w=4.5u l=0.5u
X1026 lpopamp_core_0.sliceB_1.bnb lpopamp_core_0.sliceB_1.bnb a_11750_8400# avss sg13_hv_nmos ad=1.125p pd=5u as=1.125p ps=5u w=4.5u l=0.5u
X1027 avdd en lpopamp_core_0.sliceA_0.bpa avdd sg13_hv_pmos ad=1.125p pd=5u as=1.125p ps=5u w=4.5u l=1.5u
X1028 out zp_p avdd avdd sg13_hv_pmos ad=1.125p pd=5u as=1.125p ps=5u w=4.5u l=0.5u
X1029 a_13950_7150# in_p lpopamp_core_0.sliceB_0.yp_m avss sg13_hv_nmos ad=1.125p pd=5u as=1.125p ps=5u w=4.5u l=0.5u
X1030 ib en lpopamp_core_0.sliceA_1.bna avss sg13_hv_nmos ad=1.125p pd=5u as=1.125p ps=5u w=4.5u l=1.5u
X1031 lpopamp_core_0.sliceA_1.bpb lpopamp_core_0.sliceA_1.bpb lpopamp_core_0.sliceA_1.bpa_r avdd sg13_hv_pmos ad=1.125p pd=5u as=1.125p ps=5u w=4.5u l=0.5u
X1032 lpopamp_core_0.sliceB_0.bnb lpopamp_core_0.sliceB_0.bnb a_10550_7150# avss sg13_hv_nmos ad=1.125p pd=5u as=1.125p ps=5u w=4.5u l=0.5u
X1033 lpopamp_core_0.sliceA_0.bna_ lpopamp_core_0.sliceA_0.bnb a_11150_100# avss sg13_hv_nmos ad=1.125p pd=5u as=1.125p ps=5u w=4.5u l=0.5u
X1034 a_9150_2500# lpopamp_core_0.sliceA_0.bpa_r a_9050_2500# avdd sg13_hv_pmos ad=1.125p pd=5u as=1.125p ps=5u w=4.5u l=0.5u
X1035 avdd en zp_p avdd sg13_hv_pmos ad=2.25p pd=10u as=1.125p ps=5u w=4.5u l=1.5u
X1036 a_20350_700# lpopamp_core_0.sliceA_0.bnb lpopamp_core_0.sliceA_0.zp_m avss sg13_hv_nmos ad=1.125p pd=5u as=1.125p ps=5u w=4.5u l=0.5u
X1037 zn_p lpopamp_core_0.sliceA_0.zn_m a_27350_700# avss sg13_hv_nmos ad=1.125p pd=5u as=1.125p ps=5u w=4.5u l=0.5u
X1038 a_20050_14250# lpopamp_core_0.sliceA_1.bnb a_20350_14250# avss sg13_hv_nmos ad=1.125p pd=5u as=1.125p ps=5u w=4.5u l=0.5u
X1039 a_29950_8400# zn_p out avss sg13_hv_nmos ad=1.125p pd=5u as=1.125p ps=5u w=4.5u l=0.5u
X1040 lpopamp_core_0.sliceB_0.yp_p in_m a_14950_7150# avss sg13_hv_nmos ad=1.125p pd=5u as=1.125p ps=5u w=4.5u l=0.5u
X1041 lpopamp_core_0.sliceB_1.yp_m lpopamp_core_0.sliceB_1.bpa avdd avdd sg13_hv_pmos ad=1.125p pd=5u as=1.125p ps=5u w=4.5u l=3.5u
X1042 a_22450_10200# lpopamp_core_0.sliceB_1.bpb lpopamp_core_0.sliceB_1.zn_m avdd sg13_hv_pmos ad=1.125p pd=5u as=1.125p ps=5u w=4.5u l=0.5u
X1043 zn_p lpopamp_core_0.sliceB_1.bnb a_26550_8400# avss sg13_hv_nmos ad=1.125p pd=5u as=1.125p ps=5u w=4.5u l=0.5u
X1044 lpopamp_core_0.sliceB_1.xp in_p lpopamp_core_0.sliceB_1.yn_m avdd sg13_hv_pmos ad=1.125p pd=5u as=1.125p ps=5u w=4.5u l=0.5u
X1045 a_5250_7150# lpopamp_core_0.sliceB_0.bna avss avss sg13_hv_nmos ad=1.125p pd=5u as=1.125p ps=5u w=4.5u l=3.5u
X1046 a_23350_8400# lpopamp_core_0.sliceB_1.zn_m lpopamp_core_0.sliceB_1.yn_p avss sg13_hv_nmos ad=1.125p pd=5u as=1.125p ps=5u w=4.5u l=0.5u
X1047 avdd lpopamp_core_0.sliceA_0.bpa lpopamp_core_0.sliceA_0.yp_m avdd sg13_hv_pmos ad=1.125p pd=5u as=1.125p ps=5u w=4.5u l=3.5u
X1048 a_28750_7150# zn_p out avss sg13_hv_nmos ad=1.125p pd=5u as=1.125p ps=5u w=4.5u l=0.5u
X1049 a_8550_700# lpopamp_core_0.sliceA_0.bna_ a_8450_700# avss sg13_hv_nmos ad=1.125p pd=5u as=1.125p ps=5u w=4.5u l=0.5u
X1050 lpopamp_core_0.sliceA_1.bpb lpopamp_core_0.sliceA_1.bpb lpopamp_core_0.sliceA_1.bpa_r avdd sg13_hv_pmos ad=1.125p pd=5u as=1.125p ps=5u w=4.5u l=0.5u
X1051 a_12550_700# lpopamp_core_0.sliceA_0.bna_ a_12450_700# avss sg13_hv_nmos ad=1.125p pd=5u as=1.125p ps=5u w=4.5u l=0.5u
X1052 zn_p lpopamp_core_0.sliceA_1.bpb zp_p avdd sg13_hv_pmos ad=1.125p pd=5u as=1.125p ps=5u w=4.5u l=0.5u
X1053 lpopamp_core_0.sliceB_0.yn_m in_p lpopamp_core_0.sliceB_0.xp avdd sg13_hv_pmos ad=1.125p pd=5u as=1.125p ps=5u w=4.5u l=0.5u
X1054 a_9350_7150# lpopamp_core_0.sliceB_0.bnb lpopamp_core_0.sliceB_0.bna_ avss sg13_hv_nmos ad=1.125p pd=5u as=1.125p ps=5u w=4.5u l=0.5u
X1055 out zp_p avdd avdd sg13_hv_pmos ad=1.125p pd=5u as=1.125p ps=5u w=4.5u l=0.5u
X1056 avss lpopamp_core_0.sliceA_1.bna a_4050_14250# avss sg13_hv_nmos ad=1.125p pd=5u as=1.125p ps=5u w=4.5u l=3.5u
X1057 lpopamp_core_0.sliceA_1.yn_m in_p lpopamp_core_0.sliceA_1.xp avdd sg13_hv_pmos ad=1.125p pd=5u as=1.125p ps=5u w=4.5u l=0.5u
X1058 a_22450_7150# lpopamp_core_0.sliceB_0.zn_m avss avss sg13_hv_nmos ad=1.125p pd=5u as=1.125p ps=5u w=4.5u l=3.5u
X1059 lpopamp_core_0.sliceB_1.yp_p in_m a_14550_7800# avss sg13_hv_nmos ad=1.125p pd=5u as=1.125p ps=5u w=4.5u l=0.5u
X1060 lpopamp_core_0.sliceB_1.bpa_l lpopamp_core_0.sliceB_1.bpb lpopamp_core_0.sliceB_1.bpb avdd sg13_hv_pmos ad=1.125p pd=5u as=1.125p ps=5u w=4.5u l=0.5u
X1061 out zn_p a_28550_100# avss sg13_hv_nmos ad=1.125p pd=5u as=1.125p ps=5u w=4.5u l=0.5u
X1062 lpopamp_core_0.sliceB_0.bpb lpopamp_core_0.sliceB_0.bpb lpopamp_core_0.sliceB_0.bpa_r avdd sg13_hv_pmos ad=1.125p pd=5u as=1.125p ps=5u w=4.5u l=0.5u
X1063 a_11350_7800# lpopamp_core_0.sliceB_1.bnb lpopamp_core_0.sliceB_1.bna_ avss sg13_hv_nmos ad=1.125p pd=5u as=1.125p ps=5u w=4.5u l=0.5u
X1064 lpopamp_core_0.sliceA_1.yp_p lpopamp_core_0.sliceA_1.zp_m avdd avdd sg13_hv_pmos ad=1.125p pd=5u as=1.125p ps=5u w=4.5u l=3.5u
X1065 lpopamp_core_0.sliceB_0.yp_p lpopamp_core_0.sliceB_0.zp_m avdd avdd sg13_hv_pmos ad=1.125p pd=5u as=1.125p ps=5u w=4.5u l=3.5u
X1066 a_22450_2500# lpopamp_core_0.sliceA_0.bpb lpopamp_core_0.sliceA_0.zn_m avdd sg13_hv_pmos ad=1.125p pd=5u as=1.125p ps=5u w=4.5u l=0.5u
X1067 a_6750_3100# lpopamp_core_0.sliceA_0.bpa_l a_6650_3100# avdd sg13_hv_pmos ad=1.125p pd=5u as=1.125p ps=5u w=4.5u l=0.5u
X1068 lpopamp_core_0.sliceB_1.yp_p lpopamp_core_0.sliceB_1.zp_m lpopamp_core_0.sliceB_1.zp_m avdd sg13_hv_pmos ad=1.125p pd=5u as=1.125p ps=5u w=4.5u l=0.5u
X1069 lpopamp_core_0.sliceA_1.yn_p lpopamp_core_0.sliceA_1.zn_m a_22450_14850# avss sg13_hv_nmos ad=1.125p pd=5u as=1.125p ps=5u w=4.5u l=3.5u
X1070 out zp_p avdd avdd sg13_hv_pmos ad=1.125p pd=5u as=1.125p ps=5u w=4.5u l=0.5u
X1071 avdd lpopamp_core_0.sliceB_0.bpa_r a_11150_4150# avdd sg13_hv_pmos ad=1.125p pd=5u as=1.125p ps=5u w=4.5u l=0.5u
X1072 lpopamp_core_0.sliceB_1.bpa_r lpopamp_core_0.sliceB_1.bpb lpopamp_core_0.sliceB_1.bpb avdd sg13_hv_pmos ad=1.125p pd=5u as=1.125p ps=5u w=4.5u l=0.5u
X1073 lpopamp_core_0.sliceB_0.bpb lpopamp_core_0.sliceB_0.bpb lpopamp_core_0.sliceB_0.bpa_l avdd sg13_hv_pmos ad=1.125p pd=5u as=1.125p ps=5u w=4.5u l=0.5u
X1074 a_11350_14850# lpopamp_core_0.sliceA_1.bnb lpopamp_core_0.sliceA_1.bna_ avss sg13_hv_nmos ad=1.125p pd=5u as=1.125p ps=5u w=4.5u l=0.5u
X1075 lpopamp_core_0.sliceA_1.bpb lpopamp_core_0.sliceA_1.bpb lpopamp_core_0.sliceA_1.bpa_r avdd sg13_hv_pmos ad=1.125p pd=5u as=1.125p ps=5u w=4.5u l=0.5u
X1076 avdd lpopamp_core_0.sliceA_1.bpa lpopamp_core_0.sliceA_1.xp avdd sg13_hv_pmos ad=1.125p pd=5u as=1.125p ps=5u w=4.5u l=3.5u
X1077 a_10150_6550# lpopamp_core_0.sliceB_0.bnb lpopamp_core_0.sliceB_0.bna_ avss sg13_hv_nmos ad=1.125p pd=5u as=1.125p ps=5u w=4.5u l=0.5u
X1078 a_8950_7800# lpopamp_core_0.sliceB_1.bnb lpopamp_core_0.sliceB_1.bna_ avss sg13_hv_nmos ad=1.125p pd=5u as=1.125p ps=5u w=4.5u l=0.5u
X1079 zp_p lpopamp_core_0.sliceA_1.bnb a_26350_14850# avss sg13_hv_nmos ad=1.125p pd=5u as=1.125p ps=5u w=4.5u l=0.5u
X1080 lpopamp_core_0.sliceA_0.yp_m lpopamp_core_0.sliceA_0.zp_m zp_p avdd sg13_hv_pmos ad=1.125p pd=5u as=1.125p ps=5u w=4.5u l=0.5u
X1081 a_9750_100# lpopamp_core_0.sliceA_0.bnb lpopamp_core_0.sliceA_0.bna_ avss sg13_hv_nmos ad=1.125p pd=5u as=1.125p ps=5u w=4.5u l=0.5u
X1082 lpopamp_core_0.sliceA_1.xn in_p a_15150_14850# avss sg13_hv_nmos ad=1.125p pd=5u as=1.125p ps=5u w=4.5u l=0.5u
X1083 avdd lpopamp_core_0.sliceB_1.bpa lpopamp_core_0.sliceB_1.xp avdd sg13_hv_pmos ad=1.125p pd=5u as=1.125p ps=5u w=4.5u l=3.5u
X1084 a_29050_10800# zp_p out avdd sg13_hv_pmos ad=1.125p pd=5u as=1.125p ps=5u w=4.5u l=0.5u
X1085 lpopamp_core_0.sliceB_0.yp_p lpopamp_core_0.sliceB_0.zp_m avdd avdd sg13_hv_pmos ad=1.125p pd=5u as=1.125p ps=5u w=4.5u l=3.5u
X1086 avss lpopamp_core_0.sliceB_1.bna a_21650_7800# avss sg13_hv_nmos ad=1.125p pd=5u as=1.125p ps=5u w=4.5u l=3.5u
X1087 lpopamp_core_0.sliceA_0.xn in_m a_13950_700# avss sg13_hv_nmos ad=1.125p pd=5u as=1.125p ps=5u w=4.5u l=0.5u
X1088 a_13750_100# in_m lpopamp_core_0.sliceA_0.xn avss sg13_hv_nmos ad=1.125p pd=5u as=1.125p ps=5u w=4.5u l=0.5u
X1089 lpopamp_core_0.sliceB_0.yp_m lpopamp_core_0.sliceB_0.zp_m avdd avdd sg13_hv_pmos ad=1.125p pd=5u as=1.125p ps=5u w=4.5u l=3.5u
X1090 avdd lpopamp_core_0.sliceB_0.bpa_l a_8750_4150# avdd sg13_hv_pmos ad=1.125p pd=5u as=1.125p ps=5u w=4.5u l=0.5u
X1091 out zn_p a_29350_7800# avss sg13_hv_nmos ad=1.125p pd=5u as=1.125p ps=5u w=4.5u l=0.5u
X1092 a_29950_700# zn_p out avss sg13_hv_nmos ad=1.125p pd=5u as=1.125p ps=5u w=4.5u l=0.5u
X1093 lpopamp_core_0.sliceA_0.bpa_r lpopamp_core_0.sliceA_0.bpb lpopamp_core_0.sliceA_0.bpb avdd sg13_hv_pmos ad=1.125p pd=5u as=1.125p ps=5u w=4.5u l=0.5u
X1094 avss en lpopamp_core_0.sliceB_1.enb avss sg13_hv_nmos ad=1.125p pd=5u as=1.125p ps=5u w=4.5u l=1.5u
X1095 lpopamp_core_0.sliceB_0.zn_m lpopamp_core_0.sliceB_0.zn_m a_23750_6550# avss sg13_hv_nmos ad=1.125p pd=5u as=1.125p ps=5u w=4.5u l=0.5u
X1096 avss lpopamp_core_0.sliceB_0.bna a_7650_6550# avss sg13_hv_nmos ad=1.125p pd=5u as=1.125p ps=5u w=4.5u l=3.5u
X1097 lpopamp_core_0.sliceA_0.yn_m in_p lpopamp_core_0.sliceA_0.xp avdd sg13_hv_pmos ad=1.125p pd=5u as=1.125p ps=5u w=4.5u l=0.5u
X1098 lpopamp_core_0.sliceB_0.yp_p lpopamp_core_0.sliceB_0.zp_m lpopamp_core_0.sliceB_0.zp_m avdd sg13_hv_pmos ad=1.125p pd=5u as=1.125p ps=5u w=4.5u l=0.5u
X1099 a_9050_4750# lpopamp_core_0.sliceB_0.bpa_r a_8950_4750# avdd sg13_hv_pmos ad=1.125p pd=5u as=1.125p ps=5u w=4.5u l=0.5u
X1100 a_26150_7800# lpopamp_core_0.sliceB_1.zn_m lpopamp_core_0.sliceB_1.yn_m avss sg13_hv_nmos ad=1.125p pd=5u as=1.125p ps=5u w=4.5u l=0.5u
X1101 lpopamp_core_0.sliceA_0.zn_m lpopamp_core_0.sliceA_0.zn_m a_22950_100# avss sg13_hv_nmos ad=1.125p pd=5u as=1.125p ps=5u w=4.5u l=0.5u
X1102 a_20550_6550# lpopamp_core_0.sliceB_0.bnb a_20050_6550# avss sg13_hv_nmos ad=1.125p pd=5u as=1.125p ps=5u w=4.5u l=0.5u
X1103 avss en lpopamp_core_0.sliceA_1.enb avss sg13_hv_nmos ad=1.125p pd=5u as=1.125p ps=5u w=4.5u l=1.5u
X1104 lpopamp_core_0.sliceA_1.bpb lpopamp_core_0.sliceA_1.bpb lpopamp_core_0.sliceA_1.bpa_l avdd sg13_hv_pmos ad=1.125p pd=5u as=1.125p ps=5u w=4.5u l=0.5u
X1105 out zp_p avdd avdd sg13_hv_pmos ad=1.125p pd=5u as=1.125p ps=5u w=4.5u l=0.5u
X1106 lpopamp_core_0.sliceB_1.bpb lpopamp_core_0.sliceB_1.bpb lpopamp_core_0.sliceB_1.bpa_r avdd sg13_hv_pmos ad=1.125p pd=5u as=1.125p ps=5u w=4.5u l=0.5u
X1107 lpopamp_core_0.sliceB_0.yp_m lpopamp_core_0.sliceB_0.zp_m zp_p avdd sg13_hv_pmos ad=1.125p pd=5u as=1.125p ps=5u w=4.5u l=0.5u
X1108 a_23350_14250# lpopamp_core_0.sliceA_1.zn_m lpopamp_core_0.sliceA_1.yn_p avss sg13_hv_nmos ad=1.125p pd=5u as=1.125p ps=5u w=4.5u l=0.5u
X1109 out zp_p avdd avdd sg13_hv_pmos ad=1.125p pd=5u as=1.125p ps=5u w=4.5u l=0.5u
X1110 a_12150_14250# lpopamp_core_0.sliceA_1.bna_ lpopamp_core_0.sliceA_1.bna_ avss sg13_hv_nmos ad=1.125p pd=5u as=1.125p ps=5u w=4.5u l=0.5u
X1111 lpopamp_core_0.sliceA_1.yn_m lpopamp_core_0.sliceA_1.zn_m a_27150_14250# avss sg13_hv_nmos ad=1.125p pd=5u as=1.125p ps=5u w=4.5u l=0.5u
X1112 avss lpopamp_core_0.sliceA_0.bna a_4050_100# avss sg13_hv_nmos ad=1.125p pd=5u as=1.125p ps=5u w=4.5u l=3.5u
X1113 lpopamp_core_0.sliceA_0.xn in_p a_15150_100# avss sg13_hv_nmos ad=1.125p pd=5u as=1.125p ps=5u w=4.5u l=0.5u
X1114 lpopamp_core_0.sliceB_1.zp_m lpopamp_core_0.sliceB_1.zp_m lpopamp_core_0.sliceB_1.yp_p avdd sg13_hv_pmos ad=1.125p pd=5u as=1.125p ps=5u w=4.5u l=0.5u
X1115 zn_p lpopamp_core_0.sliceA_0.bpb zp_p avdd sg13_hv_pmos ad=1.125p pd=5u as=1.125p ps=5u w=4.5u l=0.5u
X1116 lpopamp_core_0.sliceA_0.bpb lpopamp_core_0.sliceA_0.bpb lpopamp_core_0.sliceA_0.bpa_r avdd sg13_hv_pmos ad=1.125p pd=5u as=1.125p ps=5u w=4.5u l=0.5u
X1117 lpopamp_core_0.sliceB_1.xn lpopamp_core_0.sliceB_1.bna a_13250_8400# avss sg13_hv_nmos ad=1.125p pd=5u as=1.125p ps=5u w=4.5u l=3.5u
X1118 lpopamp_core_0.sliceB_1.bna_ lpopamp_core_0.sliceB_1.bnb a_9950_8400# avss sg13_hv_nmos ad=1.125p pd=5u as=1.125p ps=5u w=4.5u l=0.5u
X1119 out zp_p avdd avdd sg13_hv_pmos ad=1.125p pd=5u as=1.125p ps=5u w=4.5u l=0.5u
X1120 a_12150_7150# lpopamp_core_0.sliceB_0.bna_ lpopamp_core_0.sliceB_0.bna_ avss sg13_hv_nmos ad=1.125p pd=5u as=1.125p ps=5u w=4.5u l=0.5u
X1121 lpopamp_core_0.sliceB_1.bpa_l lpopamp_core_0.sliceB_1.bpa_l a_6750_10200# avdd sg13_hv_pmos ad=1.125p pd=5u as=1.125p ps=5u w=4.5u l=0.5u
X1122 a_23750_8400# lpopamp_core_0.sliceB_1.zn_m lpopamp_core_0.sliceB_1.yn_p avss sg13_hv_nmos ad=1.125p pd=5u as=1.125p ps=5u w=4.5u l=0.5u
X1123 a_20050_7800# lpopamp_core_0.sliceB_1.bnb a_20350_8400# avss sg13_hv_nmos ad=1.125p pd=5u as=1.125p ps=5u w=4.5u l=0.5u
X1124 lpopamp_core_0.sliceA_0.yn_p lpopamp_core_0.sliceA_0.zn_m a_16450_700# avss sg13_hv_nmos ad=1.125p pd=5u as=1.125p ps=5u w=4.5u l=3.5u
X1125 zn_p lpopamp_core_0.sliceB_0.zn_m a_25750_7150# avss sg13_hv_nmos ad=1.125p pd=5u as=1.125p ps=5u w=4.5u l=0.5u
X1126 a_9750_7150# lpopamp_core_0.sliceB_0.bnb lpopamp_core_0.sliceB_0.bna_ avss sg13_hv_nmos ad=1.125p pd=5u as=1.125p ps=5u w=4.5u l=0.5u
X1127 lpopamp_core_0.sliceB_1.yp_p lpopamp_core_0.sliceB_1.zp_m lpopamp_core_0.sliceB_1.zp_m avdd sg13_hv_pmos ad=1.125p pd=5u as=1.125p ps=5u w=4.5u l=0.5u
X1128 zp_p lpopamp_core_0.sliceA_1.bpb zn_p avdd sg13_hv_pmos ad=1.125p pd=5u as=1.125p ps=5u w=4.5u l=0.5u
X1129 avss lpopamp_core_0.sliceB_1.zn_m a_28050_8400# avss sg13_hv_nmos ad=1.125p pd=5u as=1.125p ps=5u w=4.5u l=3.5u
X1130 a_10350_14850# lpopamp_core_0.sliceA_1.bnb lpopamp_core_0.sliceA_1.bnb avss sg13_hv_nmos ad=1.125p pd=5u as=1.125p ps=5u w=4.5u l=0.5u
X1131 a_8550_12450# lpopamp_core_0.sliceA_1.bpa_l lpopamp_core_0.sliceA_1.bpa_l avdd sg13_hv_pmos ad=1.125p pd=5u as=1.125p ps=5u w=4.5u l=0.5u
X1132 lpopamp_core_0.sliceB_1.zn_m lpopamp_core_0.sliceB_1.bpb a_23850_10200# avdd sg13_hv_pmos ad=1.125p pd=5u as=1.125p ps=5u w=4.5u l=0.5u
X1133 lpopamp_core_0.sliceB_0.yn_p lpopamp_core_0.sliceB_0.zn_m a_22450_7150# avss sg13_hv_nmos ad=1.125p pd=5u as=1.125p ps=5u w=4.5u l=3.5u
X1134 lpopamp_core_0.sliceA_0.xp in_m lpopamp_core_0.sliceA_0.yn_p avdd sg13_hv_pmos ad=1.125p pd=5u as=1.125p ps=5u w=4.5u l=0.5u
X1135 lpopamp_core_0.sliceA_1.yp_p in_m a_14150_14850# avss sg13_hv_nmos ad=1.125p pd=5u as=1.125p ps=5u w=4.5u l=0.5u
X1136 a_29350_14850# zn_p avss avss sg13_hv_nmos ad=1.125p pd=5u as=1.125p ps=5u w=4.5u l=0.5u
X1137 lpopamp_core_0.sliceB_1.yp_m lpopamp_core_0.sliceB_1.zp_m zp_p avdd sg13_hv_pmos ad=1.125p pd=5u as=1.125p ps=5u w=4.5u l=0.5u
X1138 lpopamp_core_0.sliceB_0.bpb lpopamp_core_0.sliceB_0.bpb lpopamp_core_0.sliceB_0.bpa_r avdd sg13_hv_pmos ad=1.125p pd=5u as=1.125p ps=5u w=4.5u l=0.5u
X1139 a_11750_7800# lpopamp_core_0.sliceB_1.bnb lpopamp_core_0.sliceB_1.bna_ avss sg13_hv_nmos ad=1.125p pd=5u as=1.125p ps=5u w=4.5u l=0.5u
X1140 lpopamp_core_0.sliceA_1.yn_m lpopamp_core_0.sliceA_1.zn_m a_18050_14850# avss sg13_hv_nmos ad=1.125p pd=5u as=1.125p ps=5u w=4.5u l=3.5u
X1141 lpopamp_core_0.sliceB_0.xp in_m lpopamp_core_0.sliceB_0.yn_p avdd sg13_hv_pmos ad=1.125p pd=5u as=1.125p ps=5u w=4.5u l=0.5u
X1142 avdd lpopamp_core_0.sliceB_0.zp_m lpopamp_core_0.sliceB_0.yp_p avdd sg13_hv_pmos ad=1.125p pd=5u as=1.125p ps=5u w=4.5u l=3.5u
X1143 lpopamp_core_0.sliceB_0.yp_m in_p a_13750_6550# avss sg13_hv_nmos ad=1.125p pd=5u as=1.125p ps=5u w=4.5u l=0.5u
X1144 a_16450_7800# lpopamp_core_0.sliceB_1.zn_m avss avss sg13_hv_nmos ad=1.125p pd=5u as=1.125p ps=5u w=4.5u l=3.5u
X1145 a_10550_6550# lpopamp_core_0.sliceB_0.bnb lpopamp_core_0.sliceB_0.bna_ avss sg13_hv_nmos ad=1.125p pd=5u as=1.125p ps=5u w=4.5u l=0.5u
X1146 lpopamp_core_0.sliceA_1.bpb lpopamp_core_0.sliceA_1.bpb lpopamp_core_0.sliceA_1.bpa_l avdd sg13_hv_pmos ad=1.125p pd=5u as=1.125p ps=5u w=4.5u l=0.5u
X1147 lpopamp_core_0.sliceB_0.yp_p lpopamp_core_0.sliceB_0.zp_m avdd avdd sg13_hv_pmos ad=1.125p pd=5u as=1.125p ps=5u w=4.5u l=3.5u
X1148 zn_p lpopamp_core_0.sliceA_0.bpb zp_p avdd sg13_hv_pmos ad=1.125p pd=5u as=1.125p ps=5u w=4.5u l=0.5u
X1149 a_8950_10800# lpopamp_core_0.sliceB_1.bpa_r avdd avdd sg13_hv_pmos ad=1.125p pd=5u as=1.125p ps=5u w=4.5u l=0.5u
X1150 a_18050_100# lpopamp_core_0.sliceA_0.zn_m avss avss sg13_hv_nmos ad=1.125p pd=5u as=1.125p ps=5u w=4.5u l=3.5u
X1151 lpopamp_core_0.sliceA_0.bnb lpopamp_core_0.sliceA_0.bnb a_10550_100# avss sg13_hv_nmos ad=1.125p pd=5u as=1.125p ps=5u w=4.5u l=0.5u
X1152 a_9150_14850# lpopamp_core_0.sliceA_1.bnb lpopamp_core_0.sliceA_1.bnb avss sg13_hv_nmos ad=1.125p pd=5u as=1.125p ps=5u w=4.5u l=0.5u
X1153 lpopamp_core_0.sliceA_0.zn_m lpopamp_core_0.sliceA_0.bpb a_23850_2500# avdd sg13_hv_pmos ad=1.125p pd=5u as=1.125p ps=5u w=4.5u l=0.5u
X1154 lpopamp_core_0.sliceA_0.bpa_l lpopamp_core_0.sliceA_0.bpb lpopamp_core_0.sliceA_0.bpb avdd sg13_hv_pmos ad=1.125p pd=5u as=1.125p ps=5u w=4.5u l=0.5u
X1155 avdd zp_p out avdd sg13_hv_pmos ad=1.125p pd=5u as=1.125p ps=5u w=4.5u l=0.5u
X1156 out zn_p a_29750_7800# avss sg13_hv_nmos ad=1.125p pd=5u as=1.125p ps=5u w=4.5u l=0.5u
X1157 zp_p lpopamp_core_0.sliceA_0.bnb a_26750_700# avss sg13_hv_nmos ad=1.125p pd=5u as=1.125p ps=5u w=4.5u l=0.5u
X1158 a_10950_10200# lpopamp_core_0.sliceB_1.bpa_r lpopamp_core_0.sliceB_1.bpa_r avdd sg13_hv_pmos ad=1.125p pd=5u as=1.125p ps=5u w=4.5u l=0.5u
X1159 avdd lpopamp_core_0.sliceA_0.bpa lpopamp_core_0.sliceA_0.xp avdd sg13_hv_pmos ad=1.125p pd=5u as=1.125p ps=5u w=4.5u l=3.5u
X1160 zp_p lpopamp_core_0.sliceB_0.zp_m lpopamp_core_0.sliceB_0.yp_m avdd sg13_hv_pmos ad=1.125p pd=5u as=1.125p ps=5u w=4.5u l=0.5u
X1161 lpopamp_core_0.sliceB_0.bpa_r lpopamp_core_0.sliceB_0.bpb lpopamp_core_0.sliceB_0.bpb avdd sg13_hv_pmos ad=1.125p pd=5u as=1.125p ps=5u w=4.5u l=0.5u
X1162 a_26550_7800# lpopamp_core_0.sliceB_1.bnb zp_p avss sg13_hv_nmos ad=1.125p pd=5u as=1.125p ps=5u w=4.5u l=0.5u
X1163 a_11150_14250# lpopamp_core_0.sliceA_1.bnb lpopamp_core_0.sliceA_1.bnb avss sg13_hv_nmos ad=1.125p pd=5u as=1.125p ps=5u w=4.5u l=0.5u
X1164 zn_p lpopamp_core_0.sliceA_0.bnb a_26950_100# avss sg13_hv_nmos ad=1.125p pd=5u as=1.125p ps=5u w=4.5u l=0.5u
X1165 zn_p lpopamp_core_0.sliceA_1.zn_m a_26150_14250# avss sg13_hv_nmos ad=1.125p pd=5u as=1.125p ps=5u w=4.5u l=0.5u
X1166 a_20950_6550# lpopamp_core_0.sliceB_0.bnb a_20050_6550# avss sg13_hv_nmos ad=1.125p pd=5u as=1.125p ps=5u w=4.5u l=0.5u
X1167 out zp_p avdd avdd sg13_hv_pmos ad=1.125p pd=5u as=1.125p ps=5u w=4.5u l=0.5u
X1168 out zp_p avdd avdd sg13_hv_pmos ad=1.125p pd=5u as=1.125p ps=5u w=4.5u l=0.5u
X1169 lpopamp_core_0.sliceA_1.yp_m in_p a_14950_14250# avss sg13_hv_nmos ad=1.125p pd=5u as=1.125p ps=5u w=4.5u l=0.5u
X1170 lpopamp_core_0.sliceB_1.yn_p in_m lpopamp_core_0.sliceB_1.xp avdd sg13_hv_pmos ad=1.125p pd=5u as=1.125p ps=5u w=4.5u l=0.5u
X1171 avdd lpopamp_core_0.sliceB_0.bpa lpopamp_core_0.sliceB_0.bpa avdd sg13_hv_pmos ad=1.125p pd=5u as=1.125p ps=5u w=4.5u l=3.5u
X1172 out zn_p a_28550_6550# avss sg13_hv_nmos ad=1.125p pd=5u as=1.125p ps=5u w=4.5u l=0.5u
X1173 lpopamp_core_0.sliceB_1.yn_p lpopamp_core_0.sliceB_1.zn_m a_23150_7800# avss sg13_hv_nmos ad=1.125p pd=5u as=1.125p ps=5u w=4.5u l=0.5u
X1174 avdd zp_p out avdd sg13_hv_pmos ad=1.125p pd=5u as=1.125p ps=5u w=4.5u l=0.5u
X1175 lpopamp_core_0.sliceB_0.yn_m lpopamp_core_0.sliceB_0.zn_m a_25250_6550# avss sg13_hv_nmos ad=1.125p pd=5u as=1.125p ps=5u w=4.5u l=3.5u
X1176 lpopamp_core_0.sliceB_0.bna_ lpopamp_core_0.sliceB_0.bnb a_9150_6550# avss sg13_hv_nmos ad=1.125p pd=5u as=1.125p ps=5u w=4.5u l=0.5u
X1177 avdd lpopamp_core_0.sliceB_0.bpa a_22450_4150# avdd sg13_hv_pmos ad=1.125p pd=5u as=1.125p ps=5u w=4.5u l=3.5u
X1178 zp_p lpopamp_core_0.sliceA_1.bpb zn_p avdd sg13_hv_pmos ad=1.125p pd=5u as=1.125p ps=5u w=4.5u l=0.5u
X1179 a_11950_700# lpopamp_core_0.sliceA_0.bnb lpopamp_core_0.sliceA_0.bnb avss sg13_hv_nmos ad=1.125p pd=5u as=1.125p ps=5u w=4.5u l=0.5u
X1180 lpopamp_core_0.sliceB_0.bpa_l lpopamp_core_0.sliceB_0.bpb lpopamp_core_0.sliceB_0.bpb avdd sg13_hv_pmos ad=1.125p pd=5u as=1.125p ps=5u w=4.5u l=0.5u
X1181 lpopamp_core_0.sliceA_1.enb en avss avss sg13_hv_nmos ad=1.125p pd=5u as=2.25p ps=10u w=4.5u l=1.5u
X1182 lpopamp_core_0.sliceA_1.yn_p in_m lpopamp_core_0.sliceA_1.xp avdd sg13_hv_pmos ad=1.125p pd=5u as=1.125p ps=5u w=4.5u l=0.5u
X1183 a_8150_100# lpopamp_core_0.sliceA_0.bna_ avss avss sg13_hv_nmos ad=1.125p pd=5u as=1.125p ps=5u w=4.5u l=0.5u
X1184 a_12150_100# lpopamp_core_0.sliceA_0.bna_ lpopamp_core_0.sliceA_0.bna_ avss sg13_hv_nmos ad=1.125p pd=5u as=1.125p ps=5u w=4.5u l=0.5u
X1185 lpopamp_core_0.sliceA_0.bpb lpopamp_core_0.sliceA_0.bpb lpopamp_core_0.sliceA_0.bpa_r avdd sg13_hv_pmos ad=1.125p pd=5u as=1.125p ps=5u w=4.5u l=0.5u
X1186 lpopamp_core_0.sliceB_1.bpb lpopamp_core_0.sliceB_1.bpb lpopamp_core_0.sliceB_1.bpa_r avdd sg13_hv_pmos ad=1.125p pd=5u as=1.125p ps=5u w=4.5u l=0.5u
X1187 a_13750_8400# in_p lpopamp_core_0.sliceB_1.xn avss sg13_hv_nmos ad=1.125p pd=5u as=1.125p ps=5u w=4.5u l=0.5u
X1188 a_20050_100# lpopamp_core_0.sliceA_0.bnb a_21150_700# avss sg13_hv_nmos ad=1.125p pd=5u as=1.125p ps=5u w=4.5u l=0.5u
X1189 a_20950_100# lpopamp_core_0.sliceA_0.bnb a_20050_100# avss sg13_hv_nmos ad=1.125p pd=5u as=1.125p ps=5u w=4.5u l=0.5u
X1190 lpopamp_core_0.sliceA_0.zn_m lpopamp_core_0.sliceA_0.bpb a_22450_2500# avdd sg13_hv_pmos ad=1.125p pd=5u as=1.125p ps=5u w=4.5u l=0.5u
X1191 a_6650_2500# lpopamp_core_0.sliceA_0.bpa_l a_6550_2500# avdd sg13_hv_pmos ad=1.125p pd=5u as=1.125p ps=5u w=4.5u l=0.5u
X1192 avss lpopamp_core_0.sliceB_1.enb zn_p avss sg13_hv_nmos ad=2.25p pd=10u as=1.125p ps=5u w=4.5u l=1.5u
X1193 a_22450_11850# lpopamp_core_0.sliceA_1.bpb lpopamp_core_0.sliceA_1.zn_m avdd sg13_hv_pmos ad=1.125p pd=5u as=1.125p ps=5u w=4.5u l=0.5u
X1194 lpopamp_core_0.sliceB_1.bna_ lpopamp_core_0.sliceB_1.bnb a_10350_8400# avss sg13_hv_nmos ad=1.125p pd=5u as=1.125p ps=5u w=4.5u l=0.5u
X1195 a_20550_14850# lpopamp_core_0.sliceA_1.bnb a_20050_14250# avss sg13_hv_nmos ad=1.125p pd=5u as=1.125p ps=5u w=4.5u l=0.5u
X1196 lpopamp_core_0.sliceB_1.yn_p lpopamp_core_0.sliceB_1.zn_m a_18050_8400# avss sg13_hv_nmos ad=1.125p pd=5u as=1.125p ps=5u w=4.5u l=3.5u
X1197 a_12550_7150# lpopamp_core_0.sliceB_0.bna_ a_12450_7150# avss sg13_hv_nmos ad=1.125p pd=5u as=1.125p ps=5u w=4.5u l=0.5u
X1198 lpopamp_core_0.sliceA_1.bpb lpopamp_core_0.sliceA_1.bpb lpopamp_core_0.sliceA_1.bpa_l avdd sg13_hv_pmos ad=1.125p pd=5u as=1.125p ps=5u w=4.5u l=0.5u
X1199 lpopamp_core_0.sliceA_1.yp_m lpopamp_core_0.sliceA_1.zp_m avdd avdd sg13_hv_pmos ad=1.125p pd=5u as=1.125p ps=5u w=4.5u l=3.5u
X1200 avdd lpopamp_core_0.sliceB_1.bpa a_22450_10200# avdd sg13_hv_pmos ad=1.125p pd=5u as=1.125p ps=5u w=4.5u l=3.5u
X1201 zp_p lpopamp_core_0.sliceA_0.zp_m lpopamp_core_0.sliceA_0.yp_m avdd sg13_hv_pmos ad=1.125p pd=5u as=1.125p ps=5u w=4.5u l=0.5u
X1202 lpopamp_core_0.sliceB_1.yn_m in_p lpopamp_core_0.sliceB_1.xp avdd sg13_hv_pmos ad=1.125p pd=5u as=1.125p ps=5u w=4.5u l=0.5u
X1203 avss en lpopamp_core_0.sliceA_0.enb avss sg13_hv_nmos ad=1.125p pd=5u as=1.125p ps=5u w=4.5u l=1.5u
X1204 lpopamp_core_0.sliceA_0.bnb lpopamp_core_0.sliceA_0.bnb a_9350_700# avss sg13_hv_nmos ad=1.125p pd=5u as=1.125p ps=5u w=4.5u l=0.5u
X1205 avss lpopamp_core_0.sliceB_1.enb lpopamp_core_0.sliceB_1.bna avss sg13_hv_nmos ad=1.125p pd=5u as=1.125p ps=5u w=4.5u l=1.5u
X1206 a_20050_7800# lpopamp_core_0.sliceB_1.bnb a_20750_8400# avss sg13_hv_nmos ad=1.125p pd=5u as=1.125p ps=5u w=4.5u l=0.5u
X1207 a_28550_8400# zn_p avss avss sg13_hv_nmos ad=1.125p pd=5u as=1.125p ps=5u w=4.5u l=0.5u
X1208 a_22950_7150# lpopamp_core_0.sliceB_0.zn_m lpopamp_core_0.sliceB_0.yn_p avss sg13_hv_nmos ad=1.125p pd=5u as=1.125p ps=5u w=4.5u l=0.5u
X1209 a_9150_8400# lpopamp_core_0.sliceB_1.bnb lpopamp_core_0.sliceB_1.bnb avss sg13_hv_nmos ad=1.125p pd=5u as=1.125p ps=5u w=4.5u l=0.5u
X1210 a_29550_100# zn_p out avss sg13_hv_nmos ad=1.125p pd=5u as=1.125p ps=5u w=4.5u l=0.5u
X1211 lpopamp_core_0.sliceB_1.bpb lpopamp_core_0.sliceB_1.bpb lpopamp_core_0.sliceB_1.bpa_l avdd sg13_hv_pmos ad=1.125p pd=5u as=1.125p ps=5u w=4.5u l=0.5u
X1212 lpopamp_core_0.sliceB_0.bna en ib avss sg13_hv_nmos ad=1.125p pd=5u as=1.125p ps=5u w=4.5u l=1.5u
X1213 a_8150_14850# lpopamp_core_0.sliceA_1.bna_ avss avss sg13_hv_nmos ad=1.125p pd=5u as=1.125p ps=5u w=4.5u l=0.5u
X1214 lpopamp_core_0.sliceB_0.xp in_m lpopamp_core_0.sliceB_0.yn_p avdd sg13_hv_pmos ad=1.125p pd=5u as=1.125p ps=5u w=4.5u l=0.5u
X1215 a_27350_7150# lpopamp_core_0.sliceB_0.zn_m lpopamp_core_0.sliceB_0.yn_m avss sg13_hv_nmos ad=1.125p pd=5u as=1.125p ps=5u w=4.5u l=0.5u
X1216 lpopamp_core_0.sliceB_1.yp_p lpopamp_core_0.sliceB_1.zp_m lpopamp_core_0.sliceB_1.zp_m avdd sg13_hv_pmos ad=1.125p pd=5u as=1.125p ps=5u w=4.5u l=0.5u
X1217 a_21650_14250# lpopamp_core_0.sliceA_1.bna a_20050_14250# avss sg13_hv_nmos ad=1.125p pd=5u as=1.125p ps=5u w=4.5u l=3.5u
X1218 a_11050_3100# lpopamp_core_0.sliceA_0.bpa_r a_10950_3100# avdd sg13_hv_pmos ad=1.125p pd=5u as=1.125p ps=5u w=4.5u l=0.5u
X1219 lpopamp_core_0.sliceB_0.yn_p lpopamp_core_0.sliceB_0.zn_m a_23950_7150# avss sg13_hv_nmos ad=1.125p pd=5u as=1.125p ps=5u w=4.5u l=0.5u
X1220 lpopamp_core_0.sliceB_1.yn_m lpopamp_core_0.sliceB_1.zn_m a_16450_7800# avss sg13_hv_nmos ad=1.125p pd=5u as=1.125p ps=5u w=4.5u l=3.5u
X1221 a_10150_14250# lpopamp_core_0.sliceA_1.bnb lpopamp_core_0.sliceA_1.bna_ avss sg13_hv_nmos ad=1.125p pd=5u as=1.125p ps=5u w=4.5u l=0.5u
X1222 out zp_p avdd avdd sg13_hv_pmos ad=1.125p pd=5u as=1.125p ps=5u w=4.5u l=0.5u
X1223 a_10950_6550# lpopamp_core_0.sliceB_0.bnb lpopamp_core_0.sliceB_0.bna_ avss sg13_hv_nmos ad=1.125p pd=5u as=1.125p ps=5u w=4.5u l=0.5u
X1224 lpopamp_core_0.sliceB_0.zp_m lpopamp_core_0.sliceB_0.zp_m lpopamp_core_0.sliceB_0.yp_p avdd sg13_hv_pmos ad=1.125p pd=5u as=1.125p ps=5u w=4.5u l=0.5u
X1225 lpopamp_core_0.sliceA_1.xn in_m a_13950_14250# avss sg13_hv_nmos ad=1.125p pd=5u as=1.125p ps=5u w=4.5u l=0.5u
X1226 lpopamp_core_0.sliceB_1.xp lpopamp_core_0.sliceB_1.bpa avdd avdd sg13_hv_pmos ad=1.125p pd=5u as=1.125p ps=5u w=4.5u l=3.5u
X1227 a_29150_14250# zn_p out avss sg13_hv_nmos ad=1.125p pd=5u as=1.125p ps=5u w=4.5u l=0.5u
X1228 lpopamp_core_0.sliceA_0.bna en ib avss sg13_hv_nmos ad=1.125p pd=5u as=1.125p ps=5u w=4.5u l=1.5u
X1229 lpopamp_core_0.sliceA_0.yp_m in_p a_14550_100# avss sg13_hv_nmos ad=1.125p pd=5u as=1.125p ps=5u w=4.5u l=0.5u
X1230 a_8650_3100# lpopamp_core_0.sliceA_0.bpa_l a_8550_3100# avdd sg13_hv_pmos ad=1.125p pd=5u as=1.125p ps=5u w=4.5u l=0.5u
X1231 a_15650_6550# lpopamp_core_0.sliceB_0.bna lpopamp_core_0.sliceB_0.xn avss sg13_hv_nmos ad=1.125p pd=5u as=1.125p ps=5u w=4.5u l=3.5u
X1232 a_22450_11850# lpopamp_core_0.sliceA_1.bpb lpopamp_core_0.sliceA_1.zn_m avdd sg13_hv_pmos ad=1.125p pd=5u as=1.125p ps=5u w=4.5u l=0.5u
X1233 a_23750_700# lpopamp_core_0.sliceA_0.zn_m lpopamp_core_0.sliceA_0.yn_p avss sg13_hv_nmos ad=1.125p pd=5u as=1.125p ps=5u w=4.5u l=0.5u
X1234 lpopamp_core_0.sliceA_1.yp_m lpopamp_core_0.sliceA_1.zp_m avdd avdd sg13_hv_pmos ad=1.125p pd=5u as=1.125p ps=5u w=4.5u l=3.5u
X1235 lpopamp_core_0.sliceA_0.yp_p lpopamp_core_0.sliceA_0.zp_m lpopamp_core_0.sliceA_0.zp_m avdd sg13_hv_pmos ad=1.125p pd=5u as=1.125p ps=5u w=4.5u l=0.5u
X1236 avdd lpopamp_core_0.sliceA_0.bpa lpopamp_core_0.sliceA_0.bpa avdd sg13_hv_pmos ad=1.125p pd=5u as=1.125p ps=5u w=4.5u l=3.5u
X1237 zp_p lpopamp_core_0.sliceB_0.bpb zn_p avdd sg13_hv_pmos ad=1.125p pd=5u as=1.125p ps=5u w=4.5u l=0.5u
X1238 lpopamp_core_0.sliceB_0.bpa_r lpopamp_core_0.sliceB_0.bpb lpopamp_core_0.sliceB_0.bpb avdd sg13_hv_pmos ad=1.125p pd=5u as=1.125p ps=5u w=4.5u l=0.5u
X1239 a_26950_7800# lpopamp_core_0.sliceB_1.bnb zp_p avss sg13_hv_nmos ad=1.125p pd=5u as=1.125p ps=5u w=4.5u l=0.5u
X1240 lpopamp_core_0.sliceB_0.bna_ lpopamp_core_0.sliceB_0.bnb a_11950_6550# avss sg13_hv_nmos ad=1.125p pd=5u as=1.125p ps=5u w=4.5u l=0.5u
X1241 out zp_p a_29050_3100# avdd sg13_hv_pmos ad=1.125p pd=5u as=1.125p ps=5u w=4.5u l=0.5u
X1242 a_22450_4150# lpopamp_core_0.sliceB_0.bpb lpopamp_core_0.sliceB_0.zn_m avdd sg13_hv_pmos ad=1.125p pd=5u as=1.125p ps=5u w=4.5u l=0.5u
X1243 a_6550_4750# lpopamp_core_0.sliceB_0.bpa_l avdd avdd sg13_hv_pmos ad=1.125p pd=5u as=1.125p ps=5u w=4.5u l=0.5u
X1244 lpopamp_core_0.sliceB_1.yn_p lpopamp_core_0.sliceB_1.zn_m a_23550_7800# avss sg13_hv_nmos ad=1.125p pd=5u as=1.125p ps=5u w=4.5u l=0.5u
X1245 a_8750_10200# lpopamp_core_0.sliceB_1.bpa_l a_8650_10200# avdd sg13_hv_pmos ad=1.125p pd=5u as=1.125p ps=5u w=4.5u l=0.5u
X1246 a_20350_7800# lpopamp_core_0.sliceB_1.bnb lpopamp_core_0.sliceB_1.zp_m avss sg13_hv_nmos ad=1.125p pd=5u as=1.125p ps=5u w=4.5u l=0.5u
X1247 lpopamp_core_0.sliceA_1.yp_p lpopamp_core_0.sliceA_1.zp_m lpopamp_core_0.sliceA_1.zp_m avdd sg13_hv_pmos ad=1.125p pd=5u as=1.125p ps=5u w=4.5u l=0.5u
X1248 a_25750_6550# lpopamp_core_0.sliceB_0.zn_m lpopamp_core_0.sliceB_0.yn_m avss sg13_hv_nmos ad=1.125p pd=5u as=1.125p ps=5u w=4.5u l=0.5u
X1249 lpopamp_core_0.sliceB_0.bna_ lpopamp_core_0.sliceB_0.bnb a_9550_6550# avss sg13_hv_nmos ad=1.125p pd=5u as=1.125p ps=5u w=4.5u l=0.5u
X1250 lpopamp_core_0.sliceA_1.bpa_r lpopamp_core_0.sliceA_1.bpb lpopamp_core_0.sliceA_1.bpb avdd sg13_hv_pmos ad=1.125p pd=5u as=1.125p ps=5u w=4.5u l=0.5u
X1251 a_23850_4150# lpopamp_core_0.sliceB_0.bpa avdd avdd sg13_hv_pmos ad=1.125p pd=5u as=1.125p ps=5u w=4.5u l=3.5u
X1252 lpopamp_core_0.sliceB_0.bpa_l lpopamp_core_0.sliceB_0.bpb lpopamp_core_0.sliceB_0.bpb avdd sg13_hv_pmos ad=1.125p pd=5u as=1.125p ps=5u w=4.5u l=0.5u
X1253 zp_p lpopamp_core_0.sliceA_1.zp_m lpopamp_core_0.sliceA_1.yp_m avdd sg13_hv_pmos ad=1.125p pd=5u as=1.125p ps=5u w=4.5u l=0.5u
X1254 a_6550_12450# lpopamp_core_0.sliceA_1.bpa_l avdd avdd sg13_hv_pmos ad=1.125p pd=5u as=1.125p ps=5u w=4.5u l=0.5u
X1255 a_22450_10200# lpopamp_core_0.sliceB_1.bpa avdd avdd sg13_hv_pmos ad=1.125p pd=5u as=1.125p ps=5u w=4.5u l=3.5u
X1256 lpopamp_core_0.sliceA_0.yn_p in_m lpopamp_core_0.sliceA_0.xp avdd sg13_hv_pmos ad=1.125p pd=5u as=1.125p ps=5u w=4.5u l=0.5u
X1257 lpopamp_core_0.sliceA_1.zn_m lpopamp_core_0.sliceA_1.zn_m a_23350_14850# avss sg13_hv_nmos ad=1.125p pd=5u as=1.125p ps=5u w=4.5u l=0.5u
X1258 a_29450_11850# zp_p out avdd sg13_hv_pmos ad=1.125p pd=5u as=1.125p ps=5u w=4.5u l=0.5u
X1259 a_16450_100# lpopamp_core_0.sliceA_0.zn_m avss avss sg13_hv_nmos ad=1.125p pd=5u as=1.125p ps=5u w=4.5u l=3.5u
X1260 lpopamp_core_0.sliceB_0.yp_p lpopamp_core_0.sliceB_0.zp_m lpopamp_core_0.sliceB_0.zp_m avdd sg13_hv_pmos ad=1.125p pd=5u as=1.125p ps=5u w=4.5u l=0.5u
X1261 a_12250_14850# lpopamp_core_0.sliceA_1.bna_ a_12150_14850# avss sg13_hv_nmos ad=1.125p pd=5u as=1.125p ps=5u w=4.5u l=0.5u
X1262 lpopamp_core_0.sliceA_1.xp in_p lpopamp_core_0.sliceA_1.yn_m avdd sg13_hv_pmos ad=1.125p pd=5u as=1.125p ps=5u w=4.5u l=0.5u
X1263 lpopamp_core_0.sliceB_1.yp_m lpopamp_core_0.sliceB_1.zp_m zp_p avdd sg13_hv_pmos ad=1.125p pd=5u as=1.125p ps=5u w=4.5u l=0.5u
X1264 a_27350_14850# lpopamp_core_0.sliceA_1.zn_m lpopamp_core_0.sliceA_1.yn_m avss sg13_hv_nmos ad=1.125p pd=5u as=1.125p ps=5u w=4.5u l=0.5u
X1265 a_25250_100# lpopamp_core_0.sliceA_0.zn_m avss avss sg13_hv_nmos ad=1.125p pd=5u as=1.125p ps=5u w=4.5u l=3.5u
X1266 a_16450_14850# lpopamp_core_0.sliceA_1.zn_m avss avss sg13_hv_nmos ad=1.125p pd=5u as=1.125p ps=5u w=4.5u l=3.5u
X1267 lpopamp_core_0.sliceB_1.yp_p lpopamp_core_0.sliceB_1.zp_m lpopamp_core_0.sliceB_1.zp_m avdd sg13_hv_pmos ad=1.125p pd=5u as=1.125p ps=5u w=4.5u l=0.5u
X1268 lpopamp_core_0.sliceB_1.bna_ lpopamp_core_0.sliceB_1.bnb a_10750_8400# avss sg13_hv_nmos ad=1.125p pd=5u as=1.125p ps=5u w=4.5u l=0.5u
X1269 a_18850_8400# lpopamp_core_0.sliceB_1.zn_m lpopamp_core_0.sliceB_1.yn_p avss sg13_hv_nmos ad=1.125p pd=5u as=1.125p ps=5u w=4.5u l=3.5u
X1270 a_13250_7150# lpopamp_core_0.sliceB_0.bna avss avss sg13_hv_nmos ad=1.125p pd=5u as=1.125p ps=5u w=4.5u l=3.5u
X1271 avdd lpopamp_core_0.sliceA_1.bpa lpopamp_core_0.sliceA_1.bpa avdd sg13_hv_pmos ad=1.125p pd=5u as=1.125p ps=5u w=4.5u l=3.5u
X1272 zp_p lpopamp_core_0.sliceA_0.bpb zn_p avdd sg13_hv_pmos ad=1.125p pd=5u as=1.125p ps=5u w=4.5u l=0.5u
X1273 lpopamp_core_0.sliceB_1.xn in_m a_15150_8400# avss sg13_hv_nmos ad=1.125p pd=5u as=1.125p ps=5u w=4.5u l=0.5u
X1274 lpopamp_core_0.sliceA_1.bpa_r lpopamp_core_0.sliceA_1.bpa_r a_9150_11850# avdd sg13_hv_pmos ad=1.125p pd=5u as=1.125p ps=5u w=4.5u l=0.5u
X1275 lpopamp_core_0.sliceB_1.bpb lpopamp_core_0.sliceB_1.bpb lpopamp_core_0.sliceB_1.bpa_l avdd sg13_hv_pmos ad=1.125p pd=5u as=1.125p ps=5u w=4.5u l=0.5u
X1276 a_23850_2500# lpopamp_core_0.sliceA_0.bpb lpopamp_core_0.sliceA_0.zn_m avdd sg13_hv_pmos ad=1.125p pd=5u as=1.125p ps=5u w=4.5u l=0.5u
X1277 lpopamp_core_0.sliceA_0.bpb lpopamp_core_0.sliceA_0.bpb lpopamp_core_0.sliceA_0.bpa_l avdd sg13_hv_pmos ad=1.125p pd=5u as=1.125p ps=5u w=4.5u l=0.5u
X1278 avss lpopamp_core_0.sliceB_0.zn_m a_17250_7150# avss sg13_hv_nmos ad=1.125p pd=5u as=1.125p ps=5u w=4.5u l=3.5u
X1279 a_10350_700# lpopamp_core_0.sliceA_0.bnb lpopamp_core_0.sliceA_0.bnb avss sg13_hv_nmos ad=1.125p pd=5u as=1.125p ps=5u w=4.5u l=0.5u
X1280 a_20350_14250# lpopamp_core_0.sliceA_1.bnb lpopamp_core_0.sliceA_1.zp_m avss sg13_hv_nmos ad=1.125p pd=5u as=1.125p ps=5u w=4.5u l=0.5u
X1281 lpopamp_core_0.sliceB_0.xn in_p a_13950_7150# avss sg13_hv_nmos ad=1.125p pd=5u as=1.125p ps=5u w=4.5u l=0.5u
X1282 a_28950_8400# zn_p avss avss sg13_hv_nmos ad=1.125p pd=5u as=1.125p ps=5u w=4.5u l=0.5u
X1283 zp_p lpopamp_core_0.sliceB_1.zp_m lpopamp_core_0.sliceB_1.yp_m avdd sg13_hv_pmos ad=1.125p pd=5u as=1.125p ps=5u w=4.5u l=0.5u
X1284 avss lpopamp_core_0.sliceA_1.zn_m a_28050_14250# avss sg13_hv_nmos ad=1.125p pd=5u as=1.125p ps=5u w=4.5u l=3.5u
X1285 lpopamp_core_0.sliceB_1.yn_m in_p lpopamp_core_0.sliceB_1.xp avdd sg13_hv_pmos ad=1.125p pd=5u as=1.125p ps=5u w=4.5u l=0.5u
X1286 a_9550_8400# lpopamp_core_0.sliceB_1.bnb lpopamp_core_0.sliceB_1.bnb avss sg13_hv_nmos ad=1.125p pd=5u as=1.125p ps=5u w=4.5u l=0.5u
X1287 zp_p lpopamp_core_0.sliceA_0.bnb a_26350_100# avss sg13_hv_nmos ad=1.125p pd=5u as=1.125p ps=5u w=4.5u l=0.5u
X1288 a_28050_7150# lpopamp_core_0.sliceB_0.zn_m lpopamp_core_0.sliceB_0.yn_m avss sg13_hv_nmos ad=1.125p pd=5u as=1.125p ps=5u w=4.5u l=3.5u
X1289 lpopamp_core_0.sliceA_1.bpa_r lpopamp_core_0.sliceA_1.bpb lpopamp_core_0.sliceA_1.bpb avdd sg13_hv_pmos ad=1.125p pd=5u as=1.125p ps=5u w=4.5u l=0.5u
X1290 zp_p lpopamp_core_0.sliceA_1.bpb zn_p avdd sg13_hv_pmos ad=1.125p pd=5u as=1.125p ps=5u w=4.5u l=0.5u
X1291 a_17250_7800# lpopamp_core_0.sliceB_1.zn_m lpopamp_core_0.sliceB_1.yn_m avss sg13_hv_nmos ad=1.125p pd=5u as=1.125p ps=5u w=4.5u l=3.5u
X1292 a_8350_7150# lpopamp_core_0.sliceB_0.bna_ a_8250_7150# avss sg13_hv_nmos ad=1.125p pd=5u as=1.125p ps=5u w=4.5u l=0.5u
X1293 lpopamp_core_0.sliceA_1.yp_m lpopamp_core_0.sliceA_1.zp_m avdd avdd sg13_hv_pmos ad=1.125p pd=5u as=1.125p ps=5u w=4.5u l=3.5u
X1294 avdd zp_p out avdd sg13_hv_pmos ad=1.125p pd=5u as=1.125p ps=5u w=4.5u l=0.5u
X1295 a_21150_7150# lpopamp_core_0.sliceB_0.bnb lpopamp_core_0.sliceB_0.zp_m avss sg13_hv_nmos ad=1.125p pd=5u as=1.125p ps=5u w=4.5u l=0.5u
X1296 lpopamp_core_0.sliceA_1.xp in_p lpopamp_core_0.sliceA_1.yn_m avdd sg13_hv_pmos ad=1.125p pd=5u as=1.125p ps=5u w=4.5u l=0.5u
X1297 lpopamp_core_0.sliceB_1.bpb lpopamp_core_0.sliceB_1.bpb lpopamp_core_0.sliceB_1.bpa_l avdd sg13_hv_pmos ad=1.125p pd=5u as=1.125p ps=5u w=4.5u l=0.5u
X1298 a_11550_100# lpopamp_core_0.sliceA_0.bnb lpopamp_core_0.sliceA_0.bnb avss sg13_hv_nmos ad=1.125p pd=5u as=1.125p ps=5u w=4.5u l=0.5u
X1299 lpopamp_core_0.sliceB_0.xp in_p lpopamp_core_0.sliceB_0.yn_m avdd sg13_hv_pmos ad=1.125p pd=5u as=1.125p ps=5u w=4.5u l=0.5u
X1300 a_10350_7800# lpopamp_core_0.sliceB_1.bnb lpopamp_core_0.sliceB_1.bnb avss sg13_hv_nmos ad=1.125p pd=5u as=1.125p ps=5u w=4.5u l=0.5u
X1301 a_28050_700# lpopamp_core_0.sliceA_0.zn_m lpopamp_core_0.sliceA_0.yn_m avss sg13_hv_nmos ad=1.125p pd=5u as=1.125p ps=5u w=4.5u l=3.5u
X1302 avss lpopamp_core_0.sliceB_0.bna a_15650_6550# avss sg13_hv_nmos ad=1.125p pd=5u as=1.125p ps=5u w=4.5u l=3.5u
X1303 lpopamp_core_0.sliceA_0.zp_m lpopamp_core_0.sliceA_0.bnb a_20550_700# avss sg13_hv_nmos ad=1.125p pd=5u as=1.125p ps=5u w=4.5u l=0.5u
X1304 lpopamp_core_0.sliceB_0.xp in_p lpopamp_core_0.sliceB_0.yn_m avdd sg13_hv_pmos ad=1.125p pd=5u as=1.125p ps=5u w=4.5u l=0.5u
X1305 avdd lpopamp_core_0.sliceA_1.bpa a_23850_11850# avdd sg13_hv_pmos ad=1.125p pd=5u as=1.125p ps=5u w=4.5u l=3.5u
X1306 lpopamp_core_0.sliceA_0.bpa lpopamp_core_0.sliceA_0.bpa avdd avdd sg13_hv_pmos ad=1.125p pd=5u as=1.125p ps=5u w=4.5u l=3.5u
X1307 a_12450_6550# lpopamp_core_0.sliceB_0.bna_ a_12350_6550# avss sg13_hv_nmos ad=1.125p pd=5u as=1.125p ps=5u w=4.5u l=0.5u
X1308 avdd lpopamp_core_0.sliceA_1.zp_m lpopamp_core_0.sliceA_1.yp_p avdd sg13_hv_pmos ad=1.125p pd=5u as=1.125p ps=5u w=4.5u l=3.5u
X1309 lpopamp_core_0.sliceB_1.zp_m lpopamp_core_0.sliceB_1.zp_m lpopamp_core_0.sliceB_1.yp_p avdd sg13_hv_pmos ad=1.125p pd=5u as=1.125p ps=5u w=4.5u l=0.5u
X1310 out zp_p a_29450_3100# avdd sg13_hv_pmos ad=1.125p pd=5u as=1.125p ps=5u w=4.5u l=0.5u
X1311 lpopamp_core_0.sliceB_0.bpa_r lpopamp_core_0.sliceB_0.bpb lpopamp_core_0.sliceB_0.bpb avdd sg13_hv_pmos ad=1.125p pd=5u as=1.125p ps=5u w=4.5u l=0.5u
X1312 lpopamp_core_0.sliceA_1.bna_ lpopamp_core_0.sliceA_1.bnb a_11150_14850# avss sg13_hv_nmos ad=1.125p pd=5u as=1.125p ps=5u w=4.5u l=0.5u
X1313 lpopamp_core_0.sliceA_1.xp in_m lpopamp_core_0.sliceA_1.yn_p avdd sg13_hv_pmos ad=1.125p pd=5u as=1.125p ps=5u w=4.5u l=0.5u
X1314 lpopamp_core_0.sliceB_0.bpb lpopamp_core_0.sliceB_0.bpb lpopamp_core_0.sliceB_0.bpa_l avdd sg13_hv_pmos ad=1.125p pd=5u as=1.125p ps=5u w=4.5u l=0.5u
X1315 a_26350_14850# lpopamp_core_0.sliceA_1.bnb zn_p avss sg13_hv_nmos ad=1.125p pd=5u as=1.125p ps=5u w=4.5u l=0.5u
X1316 lpopamp_core_0.sliceA_1.bpa_r lpopamp_core_0.sliceA_1.bpb lpopamp_core_0.sliceA_1.bpb avdd sg13_hv_pmos ad=1.125p pd=5u as=1.125p ps=5u w=4.5u l=0.5u
X1317 avdd lpopamp_core_0.sliceB_1.zp_m lpopamp_core_0.sliceB_1.yp_p avdd sg13_hv_pmos ad=1.125p pd=5u as=1.125p ps=5u w=4.5u l=3.5u
X1318 lpopamp_core_0.sliceA_0.yp_m lpopamp_core_0.sliceA_0.zp_m zp_p avdd sg13_hv_pmos ad=1.125p pd=5u as=1.125p ps=5u w=4.5u l=0.5u
X1319 a_15150_14850# in_p lpopamp_core_0.sliceA_1.yp_m avss sg13_hv_nmos ad=1.125p pd=5u as=1.125p ps=5u w=4.5u l=0.5u
X1320 lpopamp_core_0.sliceB_1.xp in_m lpopamp_core_0.sliceB_1.yn_p avdd sg13_hv_pmos ad=1.125p pd=5u as=1.125p ps=5u w=4.5u l=0.5u
X1321 a_20750_7800# lpopamp_core_0.sliceB_1.bnb lpopamp_core_0.sliceB_1.zp_m avss sg13_hv_nmos ad=1.125p pd=5u as=1.125p ps=5u w=4.5u l=0.5u
X1322 lpopamp_core_0.sliceA_0.bna_ lpopamp_core_0.sliceA_0.bna_ a_8750_700# avss sg13_hv_nmos ad=1.125p pd=5u as=1.125p ps=5u w=4.5u l=0.5u
X1323 lpopamp_core_0.sliceB_0.zn_m lpopamp_core_0.sliceB_0.bpb a_23850_4150# avdd sg13_hv_pmos ad=1.125p pd=5u as=1.125p ps=5u w=4.5u l=0.5u
X1324 zn_p lpopamp_core_0.sliceB_0.bpb zp_p avdd sg13_hv_pmos ad=1.125p pd=5u as=1.125p ps=5u w=4.5u l=0.5u
X1325 avss lpopamp_core_0.sliceA_0.bna_ a_12750_700# avss sg13_hv_nmos ad=1.125p pd=5u as=1.125p ps=5u w=4.5u l=0.5u
X1326 lpopamp_core_0.sliceB_0.bpa_l lpopamp_core_0.sliceB_0.bpb lpopamp_core_0.sliceB_0.bpb avdd sg13_hv_pmos ad=1.125p pd=5u as=1.125p ps=5u w=4.5u l=0.5u
X1327 lpopamp_core_0.sliceA_0.bnb lpopamp_core_0.sliceA_0.bnb a_8950_100# avss sg13_hv_nmos ad=1.125p pd=5u as=1.125p ps=5u w=4.5u l=0.5u
X1328 lpopamp_core_0.sliceB_0.bpa en avdd avdd sg13_hv_pmos ad=1.125p pd=5u as=1.125p ps=5u w=4.5u l=1.5u
X1329 lpopamp_core_0.sliceB_0.zn_m lpopamp_core_0.sliceB_0.bpb a_23850_4150# avdd sg13_hv_pmos ad=1.125p pd=5u as=1.125p ps=5u w=4.5u l=0.5u
X1330 lpopamp_core_0.sliceB_0.bpa_l lpopamp_core_0.sliceB_0.bpb lpopamp_core_0.sliceB_0.bpb avdd sg13_hv_pmos ad=1.125p pd=5u as=1.125p ps=5u w=4.5u l=0.5u
X1331 lpopamp_core_0.sliceB_1.bnb lpopamp_core_0.sliceB_1.bnb a_8950_7800# avss sg13_hv_nmos ad=1.125p pd=5u as=1.125p ps=5u w=4.5u l=0.5u
X1332 lpopamp_core_0.sliceA_1.bpa_l lpopamp_core_0.sliceA_1.bpb lpopamp_core_0.sliceA_1.bpb avdd sg13_hv_pmos ad=1.125p pd=5u as=1.125p ps=5u w=4.5u l=0.5u
X1333 a_22450_700# lpopamp_core_0.sliceA_0.zn_m avss avss sg13_hv_nmos ad=1.125p pd=5u as=1.125p ps=5u w=4.5u l=3.5u
X1334 avss zn_p a_29150_700# avss sg13_hv_nmos ad=1.125p pd=5u as=1.125p ps=5u w=4.5u l=0.5u
X1335 a_28950_100# zn_p avss avss sg13_hv_nmos ad=1.125p pd=5u as=1.125p ps=5u w=4.5u l=0.5u
X1336 lpopamp_core_0.sliceB_0.yn_m lpopamp_core_0.sliceB_0.zn_m a_27150_6550# avss sg13_hv_nmos ad=1.125p pd=5u as=1.125p ps=5u w=4.5u l=0.5u
X1337 avss lpopamp_core_0.sliceA_1.bna a_6050_14850# avss sg13_hv_nmos ad=1.125p pd=5u as=1.125p ps=5u w=4.5u l=3.5u
X1338 lpopamp_core_0.sliceB_1.bpa_r lpopamp_core_0.sliceB_1.bpb lpopamp_core_0.sliceB_1.bpb avdd sg13_hv_pmos ad=1.125p pd=5u as=1.125p ps=5u w=4.5u l=0.5u
X1339 avss lpopamp_core_0.sliceB_1.zn_m a_18850_8400# avss sg13_hv_nmos ad=1.125p pd=5u as=1.125p ps=5u w=4.5u l=3.5u
X1340 lpopamp_core_0.sliceA_1.yn_p lpopamp_core_0.sliceA_1.zn_m a_23150_14250# avss sg13_hv_nmos ad=1.125p pd=5u as=1.125p ps=5u w=4.5u l=0.5u
X1341 zp_p lpopamp_core_0.sliceA_0.zp_m lpopamp_core_0.sliceA_0.yp_m avdd sg13_hv_pmos ad=1.125p pd=5u as=1.125p ps=5u w=4.5u l=0.5u
X1342 avdd zp_p out avdd sg13_hv_pmos ad=1.125p pd=5u as=1.125p ps=5u w=4.5u l=0.5u
X1343 lpopamp_core_0.sliceA_1.bna_ lpopamp_core_0.sliceA_1.bnb a_11950_14250# avss sg13_hv_nmos ad=1.125p pd=5u as=1.125p ps=5u w=4.5u l=0.5u
X1344 a_27150_14250# lpopamp_core_0.sliceA_1.zn_m zn_p avss sg13_hv_nmos ad=1.125p pd=5u as=1.125p ps=5u w=4.5u l=0.5u
X1345 avdd lpopamp_core_0.sliceB_1.zp_m lpopamp_core_0.sliceB_1.yp_p avdd sg13_hv_pmos ad=1.125p pd=5u as=1.125p ps=5u w=4.5u l=3.5u
X1346 a_8550_2500# lpopamp_core_0.sliceA_0.bpa_l lpopamp_core_0.sliceA_0.bpa_l avdd sg13_hv_pmos ad=1.125p pd=5u as=1.125p ps=5u w=4.5u l=0.5u
X1347 a_12350_8400# lpopamp_core_0.sliceB_1.bna_ a_12250_8400# avss sg13_hv_nmos ad=1.125p pd=5u as=1.125p ps=5u w=4.5u l=0.5u
X1348 lpopamp_core_0.sliceA_0.bna lpopamp_core_0.sliceA_0.bna a_2850_100# avss sg13_hv_nmos ad=1.125p pd=5u as=1.125p ps=5u w=4.5u l=3.5u
X1349 a_18050_7150# lpopamp_core_0.sliceB_0.zn_m avss avss sg13_hv_nmos ad=1.125p pd=5u as=1.125p ps=5u w=4.5u l=3.5u
X1350 a_14350_700# in_m lpopamp_core_0.sliceA_0.yp_p avss sg13_hv_nmos ad=1.125p pd=5u as=1.125p ps=5u w=4.5u l=0.5u
X1351 lpopamp_core_0.sliceA_0.zp_m lpopamp_core_0.sliceA_0.zp_m lpopamp_core_0.sliceA_0.yp_p avdd sg13_hv_pmos ad=1.125p pd=5u as=1.125p ps=5u w=4.5u l=0.5u
X1352 avdd zp_p out avdd sg13_hv_pmos ad=1.125p pd=5u as=1.125p ps=5u w=4.5u l=0.5u
X1353 lpopamp_core_0.sliceB_0.xn in_p a_14350_7150# avss sg13_hv_nmos ad=1.125p pd=5u as=1.125p ps=5u w=4.5u l=0.5u
X1354 avdd zp_p out avdd sg13_hv_pmos ad=1.125p pd=5u as=1.125p ps=5u w=4.5u l=0.5u
X1355 a_9950_8400# lpopamp_core_0.sliceB_1.bnb lpopamp_core_0.sliceB_1.bnb avss sg13_hv_nmos ad=1.125p pd=5u as=1.125p ps=5u w=4.5u l=0.5u
X1356 a_11150_7150# lpopamp_core_0.sliceB_0.bnb lpopamp_core_0.sliceB_0.bnb avss sg13_hv_nmos ad=1.125p pd=5u as=1.125p ps=5u w=4.5u l=0.5u
X1357 a_6750_10200# lpopamp_core_0.sliceB_1.bpa_l a_6650_10200# avdd sg13_hv_pmos ad=1.125p pd=5u as=1.125p ps=5u w=4.5u l=0.5u
X1358 a_23350_100# lpopamp_core_0.sliceA_0.zn_m lpopamp_core_0.sliceA_0.yn_p avss sg13_hv_nmos ad=1.125p pd=5u as=1.125p ps=5u w=4.5u l=0.5u
X1359 a_23850_11850# lpopamp_core_0.sliceA_1.bpa avdd avdd sg13_hv_pmos ad=1.125p pd=5u as=1.125p ps=5u w=4.5u l=3.5u
X1360 ib en lpopamp_core_0.sliceB_1.bna avss sg13_hv_nmos ad=1.125p pd=5u as=1.125p ps=5u w=4.5u l=1.5u
X1361 a_8750_7150# lpopamp_core_0.sliceB_0.bna_ a_8650_7150# avss sg13_hv_nmos ad=1.125p pd=5u as=1.125p ps=5u w=4.5u l=0.5u
X1362 lpopamp_core_0.sliceA_1.bpa en avdd avdd sg13_hv_pmos ad=1.125p pd=5u as=1.125p ps=5u w=4.5u l=1.5u
X1363 zn_p lpopamp_core_0.sliceA_1.bpb zp_p avdd sg13_hv_pmos ad=1.125p pd=5u as=1.125p ps=5u w=4.5u l=0.5u
X1364 lpopamp_core_0.sliceB_1.zp_m lpopamp_core_0.sliceB_1.zp_m lpopamp_core_0.sliceB_1.yp_p avdd sg13_hv_pmos ad=1.125p pd=5u as=1.125p ps=5u w=4.5u l=0.5u
X1365 a_27150_8400# lpopamp_core_0.sliceB_1.zn_m zn_p avss sg13_hv_nmos ad=1.125p pd=5u as=1.125p ps=5u w=4.5u l=0.5u
X1366 lpopamp_core_0.sliceA_1.bnb lpopamp_core_0.sliceA_1.bnb a_10150_14850# avss sg13_hv_nmos ad=1.125p pd=5u as=1.125p ps=5u w=4.5u l=0.5u
X1367 a_23850_10200# lpopamp_core_0.sliceB_1.bpb lpopamp_core_0.sliceB_1.zn_m avdd sg13_hv_pmos ad=1.125p pd=5u as=1.125p ps=5u w=4.5u l=0.5u
X1368 lpopamp_core_0.sliceA_1.yn_m lpopamp_core_0.sliceA_1.zn_m a_25250_14850# avss sg13_hv_nmos ad=1.125p pd=5u as=1.125p ps=5u w=4.5u l=3.5u
X1369 lpopamp_core_0.sliceA_1.bpa_l lpopamp_core_0.sliceA_1.bpb lpopamp_core_0.sliceA_1.bpb avdd sg13_hv_pmos ad=1.125p pd=5u as=1.125p ps=5u w=4.5u l=0.5u
X1370 avss zn_p a_29150_7150# avss sg13_hv_nmos ad=1.125p pd=5u as=1.125p ps=5u w=4.5u l=0.5u
X1371 a_14150_14850# in_m lpopamp_core_0.sliceA_1.xn avss sg13_hv_nmos ad=1.125p pd=5u as=1.125p ps=5u w=4.5u l=0.5u
X1372 a_10750_7800# lpopamp_core_0.sliceB_1.bnb lpopamp_core_0.sliceB_1.bnb avss sg13_hv_nmos ad=1.125p pd=5u as=1.125p ps=5u w=4.5u l=0.5u
X1373 avss zn_p a_29150_14850# avss sg13_hv_nmos ad=1.125p pd=5u as=1.125p ps=5u w=4.5u l=0.5u
X1374 lpopamp_core_0.sliceB_0.enb en avss avss sg13_hv_nmos ad=1.125p pd=5u as=2.25p ps=10u w=4.5u l=1.5u
X1375 avss lpopamp_core_0.sliceB_0.bna_ a_12750_6550# avss sg13_hv_nmos ad=1.125p pd=5u as=1.125p ps=5u w=4.5u l=0.5u
X1376 out zp_p a_29850_3100# avdd sg13_hv_pmos ad=1.125p pd=5u as=1.125p ps=5u w=4.5u l=0.5u
X1377 avdd lpopamp_core_0.sliceB_0.zp_m lpopamp_core_0.sliceB_0.yp_m avdd sg13_hv_pmos ad=1.125p pd=5u as=1.125p ps=5u w=4.5u l=3.5u
X1378 lpopamp_core_0.sliceB_0.bpa_r lpopamp_core_0.sliceB_0.bpb lpopamp_core_0.sliceB_0.bpb avdd sg13_hv_pmos ad=1.125p pd=5u as=1.125p ps=5u w=4.5u l=0.5u
X1379 a_15150_7800# in_m lpopamp_core_0.sliceB_1.yp_p avss sg13_hv_nmos ad=1.125p pd=5u as=1.125p ps=5u w=4.5u l=0.5u
X1380 lpopamp_core_0.sliceA_1.bpa_l lpopamp_core_0.sliceA_1.bpb lpopamp_core_0.sliceA_1.bpb avdd sg13_hv_pmos ad=1.125p pd=5u as=1.125p ps=5u w=4.5u l=0.5u
X1381 lpopamp_core_0.sliceB_1.bpa lpopamp_core_0.sliceB_1.bpa avdd avdd sg13_hv_pmos ad=1.125p pd=5u as=1.125p ps=5u w=4.5u l=3.5u
X1382 lpopamp_core_0.sliceB_0.yn_p in_m lpopamp_core_0.sliceB_0.xp avdd sg13_hv_pmos ad=1.125p pd=5u as=1.125p ps=5u w=4.5u l=0.5u
X1383 avdd lpopamp_core_0.sliceB_1.bpa_l a_8750_10800# avdd sg13_hv_pmos ad=1.125p pd=5u as=1.125p ps=5u w=4.5u l=0.5u
X1384 lpopamp_core_0.sliceA_1.bnb lpopamp_core_0.sliceA_1.bnb a_8950_14850# avss sg13_hv_nmos ad=1.125p pd=5u as=1.125p ps=5u w=4.5u l=0.5u
X1385 a_6050_700# lpopamp_core_0.sliceA_0.bna lpopamp_core_0.sliceA_0.bpa avss sg13_hv_nmos ad=1.125p pd=5u as=1.125p ps=5u w=4.5u l=3.5u
X1386 lpopamp_core_0.sliceA_0.bpa_l lpopamp_core_0.sliceA_0.bpb lpopamp_core_0.sliceA_0.bpb avdd sg13_hv_pmos ad=1.125p pd=5u as=1.125p ps=5u w=4.5u l=0.5u
X1387 lpopamp_core_0.sliceB_0.yp_m lpopamp_core_0.sliceB_0.zp_m zp_p avdd sg13_hv_pmos ad=1.125p pd=5u as=1.125p ps=5u w=4.5u l=0.5u
X1388 avss zn_p a_28750_7800# avss sg13_hv_nmos ad=1.125p pd=5u as=1.125p ps=5u w=4.5u l=0.5u
X1389 lpopamp_core_0.sliceB_1.bpa_r lpopamp_core_0.sliceB_1.bpb lpopamp_core_0.sliceB_1.bpb avdd sg13_hv_pmos ad=1.125p pd=5u as=1.125p ps=5u w=4.5u l=0.5u
X1390 zp_p lpopamp_core_0.sliceB_1.bpb zn_p avdd sg13_hv_pmos ad=1.125p pd=5u as=1.125p ps=5u w=4.5u l=0.5u
X1391 lpopamp_core_0.sliceA_0.yp_p lpopamp_core_0.sliceA_0.zp_m lpopamp_core_0.sliceA_0.zp_m avdd sg13_hv_pmos ad=1.125p pd=5u as=1.125p ps=5u w=4.5u l=0.5u
X1392 avdd lpopamp_core_0.sliceB_0.bpa a_23850_4150# avdd sg13_hv_pmos ad=1.125p pd=5u as=1.125p ps=5u w=4.5u l=3.5u
X1393 lpopamp_core_0.sliceB_0.bpa_l lpopamp_core_0.sliceB_0.bpb lpopamp_core_0.sliceB_0.bpb avdd sg13_hv_pmos ad=1.125p pd=5u as=1.125p ps=5u w=4.5u l=0.5u
X1394 lpopamp_core_0.sliceA_1.bnb lpopamp_core_0.sliceA_1.bnb a_10950_14250# avss sg13_hv_nmos ad=1.125p pd=5u as=1.125p ps=5u w=4.5u l=0.5u
X1395 lpopamp_core_0.sliceB_0.bpa lpopamp_core_0.sliceB_0.bpa avdd avdd sg13_hv_pmos ad=1.125p pd=5u as=1.125p ps=5u w=4.5u l=3.5u
X1396 lpopamp_core_0.sliceB_1.bnb lpopamp_core_0.sliceB_1.bnb a_9350_7800# avss sg13_hv_nmos ad=1.125p pd=5u as=1.125p ps=5u w=4.5u l=0.5u
X1397 a_26150_14250# lpopamp_core_0.sliceA_1.zn_m lpopamp_core_0.sliceA_1.yn_m avss sg13_hv_nmos ad=1.125p pd=5u as=1.125p ps=5u w=4.5u l=0.5u
X1398 avdd zp_p out avdd sg13_hv_pmos ad=1.125p pd=5u as=1.125p ps=5u w=4.5u l=0.5u
X1399 out zp_p a_28650_4150# avdd sg13_hv_pmos ad=1.125p pd=5u as=1.125p ps=5u w=4.5u l=0.5u
X1400 zn_p lpopamp_core_0.sliceA_0.zn_m a_25750_100# avss sg13_hv_nmos ad=1.125p pd=5u as=1.125p ps=5u w=4.5u l=0.5u
X1401 lpopamp_core_0.sliceB_0.yp_p lpopamp_core_0.sliceB_0.zp_m lpopamp_core_0.sliceB_0.zp_m avdd sg13_hv_pmos ad=1.125p pd=5u as=1.125p ps=5u w=4.5u l=0.5u
X1402 avss lpopamp_core_0.sliceB_1.bna a_6050_7800# avss sg13_hv_nmos ad=1.125p pd=5u as=1.125p ps=5u w=4.5u l=3.5u
X1403 lpopamp_core_0.sliceB_1.xp in_m lpopamp_core_0.sliceB_1.yn_p avdd sg13_hv_pmos ad=1.125p pd=5u as=1.125p ps=5u w=4.5u l=0.5u
X1404 a_26150_700# lpopamp_core_0.sliceA_0.zn_m lpopamp_core_0.sliceA_0.yn_m avss sg13_hv_nmos ad=1.125p pd=5u as=1.125p ps=5u w=4.5u l=0.5u
X1405 lpopamp_core_0.sliceB_0.yn_m lpopamp_core_0.sliceB_0.zn_m a_27550_6550# avss sg13_hv_nmos ad=1.125p pd=5u as=1.125p ps=5u w=4.5u l=0.5u
X1406 lpopamp_core_0.sliceB_0.yp_m lpopamp_core_0.sliceB_0.zp_m zp_p avdd sg13_hv_pmos ad=1.125p pd=5u as=1.125p ps=5u w=4.5u l=0.5u
X1407 lpopamp_core_0.sliceB_0.bpb lpopamp_core_0.sliceB_0.bpb lpopamp_core_0.sliceB_0.bpa_r avdd sg13_hv_pmos ad=1.125p pd=5u as=1.125p ps=5u w=4.5u l=0.5u
X1408 lpopamp_core_0.sliceA_0.bnb lpopamp_core_0.sliceA_0.bpa avdd avdd sg13_hv_pmos ad=1.125p pd=5u as=1.125p ps=5u w=4.5u l=3.5u
X1409 a_8250_6550# lpopamp_core_0.sliceB_0.bna_ a_8150_6550# avss sg13_hv_nmos ad=1.125p pd=5u as=1.125p ps=5u w=4.5u l=0.5u
X1410 avdd lpopamp_core_0.sliceA_1.bpa lpopamp_core_0.sliceA_1.bnb avdd sg13_hv_pmos ad=1.125p pd=5u as=1.125p ps=5u w=4.5u l=3.5u
X1411 a_22450_4150# lpopamp_core_0.sliceB_0.bpa avdd avdd sg13_hv_pmos ad=1.125p pd=5u as=1.125p ps=5u w=4.5u l=3.5u
X1412 zn_p lpopamp_core_0.sliceA_1.bpb zp_p avdd sg13_hv_pmos ad=1.125p pd=5u as=1.125p ps=5u w=4.5u l=0.5u
X1413 lpopamp_core_0.sliceB_0.zp_m lpopamp_core_0.sliceB_0.bnb a_20950_6550# avss sg13_hv_nmos ad=1.125p pd=5u as=1.125p ps=5u w=4.5u l=0.5u
X1414 lpopamp_core_0.sliceB_1.bpa lpopamp_core_0.sliceB_1.bpa avdd avdd sg13_hv_pmos ad=1.125p pd=5u as=1.125p ps=5u w=4.5u l=3.5u
X1415 a_8950_2500# lpopamp_core_0.sliceA_0.bpa_r avdd avdd sg13_hv_pmos ad=1.125p pd=5u as=1.125p ps=5u w=4.5u l=0.5u
X1416 lpopamp_core_0.sliceB_1.bpa_r lpopamp_core_0.sliceB_1.bpb lpopamp_core_0.sliceB_1.bpb avdd sg13_hv_pmos ad=1.125p pd=5u as=1.125p ps=5u w=4.5u l=0.5u
X1417 a_12750_8400# lpopamp_core_0.sliceB_1.bna_ a_12650_8400# avss sg13_hv_nmos ad=1.125p pd=5u as=1.125p ps=5u w=4.5u l=0.5u
X1418 lpopamp_core_0.sliceA_0.bpb lpopamp_core_0.sliceA_0.bna a_6850_100# avss sg13_hv_nmos ad=1.125p pd=5u as=1.125p ps=5u w=4.5u l=3.5u
X1419 lpopamp_core_0.sliceA_0.bna_ lpopamp_core_0.sliceA_0.bnb a_11150_700# avss sg13_hv_nmos ad=1.125p pd=5u as=1.125p ps=5u w=4.5u l=0.5u
X1420 a_10950_100# lpopamp_core_0.sliceA_0.bnb lpopamp_core_0.sliceA_0.bna_ avss sg13_hv_nmos ad=1.125p pd=5u as=1.125p ps=5u w=4.5u l=0.5u
X1421 avdd lpopamp_core_0.sliceA_0.zp_m lpopamp_core_0.sliceA_0.yp_p avdd sg13_hv_pmos ad=1.125p pd=5u as=1.125p ps=5u w=4.5u l=3.5u
X1422 lpopamp_core_0.sliceA_1.zn_m lpopamp_core_0.sliceA_1.bpb a_22450_11850# avdd sg13_hv_pmos ad=1.125p pd=5u as=1.125p ps=5u w=4.5u l=0.5u
X1423 avdd en zp_p avdd sg13_hv_pmos ad=2.25p pd=10u as=1.125p ps=5u w=4.5u l=1.5u
X1424 lpopamp_core_0.sliceB_0.xn in_m a_14750_7150# avss sg13_hv_nmos ad=1.125p pd=5u as=1.125p ps=5u w=4.5u l=0.5u
X1425 lpopamp_core_0.sliceA_1.bnb lpopamp_core_0.sliceA_1.bpa avdd avdd sg13_hv_pmos ad=1.125p pd=5u as=1.125p ps=5u w=4.5u l=3.5u
X1426 avdd zp_p out avdd sg13_hv_pmos ad=1.125p pd=5u as=1.125p ps=5u w=4.5u l=0.5u
X1427 a_20050_14250# lpopamp_core_0.sliceA_1.bnb a_20350_14850# avss sg13_hv_nmos ad=1.125p pd=5u as=1.125p ps=5u w=4.5u l=0.5u
X1428 avdd lpopamp_core_0.sliceA_1.tihi lpopamp_core_0.sliceA_1.tihi avdd sg13_hv_pmos ad=1.125p pd=5u as=1.125p ps=5u w=4.5u l=9.5u
X1429 avdd en lpopamp_core_0.sliceA_0.enb avdd sg13_hv_pmos ad=1.125p pd=5u as=1.125p ps=5u w=4.5u l=1.5u
X1430 lpopamp_core_0.sliceA_1.bpa_l lpopamp_core_0.sliceA_1.bpb lpopamp_core_0.sliceA_1.bpb avdd sg13_hv_pmos ad=1.125p pd=5u as=1.125p ps=5u w=4.5u l=0.5u
X1431 a_22450_10200# lpopamp_core_0.sliceB_1.bpb lpopamp_core_0.sliceB_1.zn_m avdd sg13_hv_pmos ad=1.125p pd=5u as=1.125p ps=5u w=4.5u l=0.5u
X1432 a_27350_100# lpopamp_core_0.sliceA_0.zn_m lpopamp_core_0.sliceA_0.yn_m avss sg13_hv_nmos ad=1.125p pd=5u as=1.125p ps=5u w=4.5u l=0.5u
X1433 lpopamp_core_0.sliceA_0.zp_m lpopamp_core_0.sliceA_0.bnb a_20150_100# avss sg13_hv_nmos ad=1.125p pd=5u as=1.125p ps=5u w=4.5u l=0.5u
X1434 a_11550_7150# lpopamp_core_0.sliceB_0.bnb lpopamp_core_0.sliceB_0.bnb avss sg13_hv_nmos ad=1.125p pd=5u as=1.125p ps=5u w=4.5u l=0.5u
X1435 lpopamp_core_0.sliceB_1.yp_m lpopamp_core_0.sliceB_1.bpa avdd avdd sg13_hv_pmos ad=1.125p pd=5u as=1.125p ps=5u w=4.5u l=3.5u
X1436 zp_p lpopamp_core_0.sliceA_0.zp_m lpopamp_core_0.sliceA_0.yp_m avdd sg13_hv_pmos ad=1.125p pd=5u as=1.125p ps=5u w=4.5u l=0.5u
X1437 lpopamp_core_0.sliceB_1.xp in_p lpopamp_core_0.sliceB_1.yn_m avdd sg13_hv_pmos ad=1.125p pd=5u as=1.125p ps=5u w=4.5u l=0.5u
X1438 a_4050_8400# lpopamp_core_0.sliceB_1.bna lpopamp_core_0.sliceB_1.bna avss sg13_hv_nmos ad=1.125p pd=5u as=1.125p ps=5u w=4.5u l=3.5u
X1439 lpopamp_core_0.sliceA_0.zp_m lpopamp_core_0.sliceA_0.zp_m lpopamp_core_0.sliceA_0.yp_p avdd sg13_hv_pmos ad=1.125p pd=5u as=1.125p ps=5u w=4.5u l=0.5u
X1440 a_27550_8400# lpopamp_core_0.sliceB_1.zn_m zn_p avss sg13_hv_nmos ad=1.125p pd=5u as=1.125p ps=5u w=4.5u l=0.5u
X1441 avdd en lpopamp_core_0.sliceA_1.enb avdd sg13_hv_pmos ad=1.125p pd=5u as=1.125p ps=5u w=4.5u l=1.5u
X1442 a_8450_100# lpopamp_core_0.sliceA_0.bna_ a_8350_100# avss sg13_hv_nmos ad=1.125p pd=5u as=1.125p ps=5u w=4.5u l=0.5u
X1443 lpopamp_core_0.sliceA_0.xp in_m lpopamp_core_0.sliceA_0.yn_p avdd sg13_hv_pmos ad=1.125p pd=5u as=1.125p ps=5u w=4.5u l=0.5u
X1444 a_8150_8400# lpopamp_core_0.sliceB_1.bna_ avss avss sg13_hv_nmos ad=1.125p pd=5u as=1.125p ps=5u w=4.5u l=0.5u
X1445 a_12450_100# lpopamp_core_0.sliceA_0.bna_ a_12350_100# avss sg13_hv_nmos ad=1.125p pd=5u as=1.125p ps=5u w=4.5u l=0.5u
X1446 avss zn_p a_29550_7150# avss sg13_hv_nmos ad=1.125p pd=5u as=1.125p ps=5u w=4.5u l=0.5u
X1447 avss lpopamp_core_0.sliceA_1.bna a_4050_14850# avss sg13_hv_nmos ad=1.125p pd=5u as=1.125p ps=5u w=4.5u l=3.5u
X1448 lpopamp_core_0.sliceB_1.bpa_l lpopamp_core_0.sliceB_1.bpb lpopamp_core_0.sliceB_1.bpb avdd sg13_hv_pmos ad=1.125p pd=5u as=1.125p ps=5u w=4.5u l=0.5u
X1449 a_2850_7150# lpopamp_core_0.sliceB_0.bna avss avss sg13_hv_nmos ad=1.125p pd=5u as=1.125p ps=5u w=4.5u l=3.5u
X1450 out zn_p a_28550_700# avss sg13_hv_nmos ad=1.125p pd=5u as=1.125p ps=5u w=4.5u l=0.5u
X1451 avdd lpopamp_core_0.sliceA_0.zp_m lpopamp_core_0.sliceA_0.yp_p avdd sg13_hv_pmos ad=1.125p pd=5u as=1.125p ps=5u w=4.5u l=3.5u
X1452 a_26350_7150# lpopamp_core_0.sliceB_0.bnb zn_p avss sg13_hv_nmos ad=1.125p pd=5u as=1.125p ps=5u w=4.5u l=0.5u
X1453 a_20050_14250# lpopamp_core_0.sliceA_1.bnb a_21150_14250# avss sg13_hv_nmos ad=1.125p pd=5u as=1.125p ps=5u w=4.5u l=0.5u
X1454 lpopamp_core_0.sliceB_1.yp_m lpopamp_core_0.sliceB_1.zp_m avdd avdd sg13_hv_pmos ad=1.125p pd=5u as=1.125p ps=5u w=4.5u l=3.5u
X1455 lpopamp_core_0.sliceA_0.bpa_r lpopamp_core_0.sliceA_0.bpb lpopamp_core_0.sliceA_0.bpb avdd sg13_hv_pmos ad=1.125p pd=5u as=1.125p ps=5u w=4.5u l=0.5u
X1456 lpopamp_core_0.sliceB_0.yp_p lpopamp_core_0.sliceB_0.zp_m avdd avdd sg13_hv_pmos ad=1.125p pd=5u as=1.125p ps=5u w=4.5u l=3.5u
X1457 lpopamp_core_0.sliceA_1.bna_ lpopamp_core_0.sliceA_1.bnb a_9950_14250# avss sg13_hv_nmos ad=1.125p pd=5u as=1.125p ps=5u w=4.5u l=0.5u
X1458 lpopamp_core_0.sliceB_0.zn_m lpopamp_core_0.sliceB_0.zn_m a_22950_7150# avss sg13_hv_nmos ad=1.125p pd=5u as=1.125p ps=5u w=4.5u l=0.5u
X1459 lpopamp_core_0.sliceB_1.yp_m lpopamp_core_0.sliceB_1.zp_m avdd avdd sg13_hv_pmos ad=1.125p pd=5u as=1.125p ps=5u w=4.5u l=3.5u
X1460 avdd zp_p out avdd sg13_hv_pmos ad=1.125p pd=5u as=1.125p ps=5u w=4.5u l=0.5u
X1461 lpopamp_core_0.sliceB_0.yn_p in_m lpopamp_core_0.sliceB_0.xp avdd sg13_hv_pmos ad=1.125p pd=5u as=1.125p ps=5u w=4.5u l=0.5u
X1462 avdd lpopamp_core_0.sliceB_0.bpa_r a_11150_4750# avdd sg13_hv_pmos ad=1.125p pd=5u as=1.125p ps=5u w=4.5u l=0.5u
X1463 a_12250_7800# lpopamp_core_0.sliceB_1.bna_ a_12150_7800# avss sg13_hv_nmos ad=1.125p pd=5u as=1.125p ps=5u w=4.5u l=0.5u
X1464 avss lpopamp_core_0.sliceA_1.zn_m a_18850_14250# avss sg13_hv_nmos ad=1.125p pd=5u as=1.125p ps=5u w=4.5u l=3.5u
X1465 out zn_p a_28950_14250# avss sg13_hv_nmos ad=1.125p pd=5u as=1.125p ps=5u w=4.5u l=0.5u
X1466 a_9750_700# lpopamp_core_0.sliceA_0.bnb lpopamp_core_0.sliceA_0.bna_ avss sg13_hv_nmos ad=1.125p pd=5u as=1.125p ps=5u w=4.5u l=0.5u
X1467 lpopamp_core_0.sliceA_0.bpa_l lpopamp_core_0.sliceA_0.bpb lpopamp_core_0.sliceA_0.bpb avdd sg13_hv_pmos ad=1.125p pd=5u as=1.125p ps=5u w=4.5u l=0.5u
X1468 a_14350_6550# in_p lpopamp_core_0.sliceB_0.yp_m avss sg13_hv_nmos ad=1.125p pd=5u as=1.125p ps=5u w=4.5u l=0.5u
X1469 lpopamp_core_0.sliceA_1.zn_m lpopamp_core_0.sliceA_1.bpb a_22450_11850# avdd sg13_hv_pmos ad=1.125p pd=5u as=1.125p ps=5u w=4.5u l=0.5u
X1470 a_13750_700# in_m lpopamp_core_0.sliceA_0.xn avss sg13_hv_nmos ad=1.125p pd=5u as=1.125p ps=5u w=4.5u l=0.5u
X1471 lpopamp_core_0.sliceB_0.bnb lpopamp_core_0.sliceB_0.bpa avdd avdd sg13_hv_pmos ad=1.125p pd=5u as=1.125p ps=5u w=4.5u l=3.5u
X1472 lpopamp_core_0.sliceB_0.yp_m lpopamp_core_0.sliceB_0.zp_m avdd avdd sg13_hv_pmos ad=1.125p pd=5u as=1.125p ps=5u w=4.5u l=3.5u
X1473 avdd lpopamp_core_0.sliceB_0.bpa_l a_8750_4750# avdd sg13_hv_pmos ad=1.125p pd=5u as=1.125p ps=5u w=4.5u l=0.5u
X1474 lpopamp_core_0.sliceB_0.bnb lpopamp_core_0.sliceB_0.bnb a_10950_6550# avss sg13_hv_nmos ad=1.125p pd=5u as=1.125p ps=5u w=4.5u l=0.5u
X1475 a_25950_7800# lpopamp_core_0.sliceB_1.zn_m zn_p avss sg13_hv_nmos ad=1.125p pd=5u as=1.125p ps=5u w=4.5u l=0.5u
X1476 lpopamp_core_0.sliceB_1.bnb lpopamp_core_0.sliceB_1.bnb a_9750_7800# avss sg13_hv_nmos ad=1.125p pd=5u as=1.125p ps=5u w=4.5u l=0.5u
X1477 avdd en lpopamp_core_0.sliceB_1.bpa avdd sg13_hv_pmos ad=1.125p pd=5u as=1.125p ps=5u w=4.5u l=1.5u
X1478 avdd lpopamp_core_0.sliceA_0.zp_m lpopamp_core_0.sliceA_0.yp_m avdd sg13_hv_pmos ad=1.125p pd=5u as=1.125p ps=5u w=4.5u l=3.5u
X1479 lpopamp_core_0.sliceB_0.yp_p lpopamp_core_0.sliceB_0.zp_m lpopamp_core_0.sliceB_0.zp_m avdd sg13_hv_pmos ad=1.125p pd=5u as=1.125p ps=5u w=4.5u l=0.5u
X1480 lpopamp_core_0.sliceA_1.yp_p lpopamp_core_0.sliceA_1.zp_m avdd avdd sg13_hv_pmos ad=1.125p pd=5u as=1.125p ps=5u w=4.5u l=3.5u
X1481 lpopamp_core_0.sliceA_0.zn_m lpopamp_core_0.sliceA_0.zn_m a_22950_700# avss sg13_hv_nmos ad=1.125p pd=5u as=1.125p ps=5u w=4.5u l=0.5u
X1482 out zn_p a_29750_100# avss sg13_hv_nmos ad=1.125p pd=5u as=1.125p ps=5u w=4.5u l=0.5u
X1483 zn_p lpopamp_core_0.sliceB_0.enb avss avss sg13_hv_nmos ad=1.125p pd=5u as=1.125p ps=5u w=4.5u l=1.5u
X1484 a_6850_7800# lpopamp_core_0.sliceB_1.bna avss avss sg13_hv_nmos ad=1.125p pd=5u as=1.125p ps=5u w=4.5u l=3.5u
X1485 a_9950_14250# lpopamp_core_0.sliceA_1.bnb lpopamp_core_0.sliceA_1.bnb avss sg13_hv_nmos ad=1.125p pd=5u as=1.125p ps=5u w=4.5u l=0.5u
X1486 a_8650_10200# lpopamp_core_0.sliceB_1.bpa_l a_8550_10200# avdd sg13_hv_pmos ad=1.125p pd=5u as=1.125p ps=5u w=4.5u l=0.5u
X1487 zn_p lpopamp_core_0.sliceB_0.bpb zp_p avdd sg13_hv_pmos ad=1.125p pd=5u as=1.125p ps=5u w=4.5u l=0.5u
X1488 out zp_p avdd avdd sg13_hv_pmos ad=1.125p pd=5u as=1.125p ps=5u w=4.5u l=0.5u
X1489 avdd lpopamp_core_0.sliceA_0.bpa lpopamp_core_0.sliceA_0.bnb avdd sg13_hv_pmos ad=1.125p pd=5u as=1.125p ps=5u w=4.5u l=3.5u
X1490 lpopamp_core_0.sliceB_0.bpb lpopamp_core_0.sliceB_0.bpb lpopamp_core_0.sliceB_0.bpa_r avdd sg13_hv_pmos ad=1.125p pd=5u as=1.125p ps=5u w=4.5u l=0.5u
X1491 a_8650_6550# lpopamp_core_0.sliceB_0.bna_ a_8550_6550# avss sg13_hv_nmos ad=1.125p pd=5u as=1.125p ps=5u w=4.5u l=0.5u
X1492 lpopamp_core_0.sliceA_1.zp_m lpopamp_core_0.sliceA_1.zp_m lpopamp_core_0.sliceA_1.yp_p avdd sg13_hv_pmos ad=1.125p pd=5u as=1.125p ps=5u w=4.5u l=0.5u
X1493 lpopamp_core_0.sliceA_1.bpb lpopamp_core_0.sliceA_1.bpb lpopamp_core_0.sliceA_1.bpa_r avdd sg13_hv_pmos ad=1.125p pd=5u as=1.125p ps=5u w=4.5u l=0.5u
X1494 lpopamp_core_0.sliceB_0.zn_m lpopamp_core_0.sliceB_0.bpb a_22450_4150# avdd sg13_hv_pmos ad=1.125p pd=5u as=1.125p ps=5u w=4.5u l=0.5u
X1495 lpopamp_core_0.sliceB_0.yp_m lpopamp_core_0.sliceB_0.zp_m zp_p avdd sg13_hv_pmos ad=1.125p pd=5u as=1.125p ps=5u w=4.5u l=0.5u
X1496 zn_p lpopamp_core_0.sliceB_1.bnb a_26950_7800# avss sg13_hv_nmos ad=1.125p pd=5u as=1.125p ps=5u w=4.5u l=0.5u
X1497 lpopamp_core_0.sliceA_1.tihi lpopamp_core_0.sliceA_1.tihi avdd avdd sg13_hv_pmos ad=1.125p pd=5u as=1.125p ps=5u w=4.5u l=9.5u
X1498 lpopamp_core_0.sliceA_1.yp_m lpopamp_core_0.sliceA_1.zp_m zp_p avdd sg13_hv_pmos ad=1.125p pd=5u as=1.125p ps=5u w=4.5u l=0.5u
X1499 lpopamp_core_0.sliceB_0.bpa lpopamp_core_0.sliceB_0.bna a_5250_6550# avss sg13_hv_nmos ad=1.125p pd=5u as=1.125p ps=5u w=4.5u l=3.5u
X1500 a_23350_14850# lpopamp_core_0.sliceA_1.zn_m lpopamp_core_0.sliceA_1.yn_p avss sg13_hv_nmos ad=1.125p pd=5u as=1.125p ps=5u w=4.5u l=0.5u
X1501 out zp_p avdd avdd sg13_hv_pmos ad=1.125p pd=5u as=1.125p ps=5u w=4.5u l=0.5u
X1502 lpopamp_core_0.sliceA_0.xp lpopamp_core_0.sliceA_0.bpa avdd avdd sg13_hv_pmos ad=1.125p pd=5u as=1.125p ps=5u w=4.5u l=3.5u
X1503 a_29150_6550# zn_p out avss sg13_hv_nmos ad=1.125p pd=5u as=1.125p ps=5u w=4.5u l=0.5u
X1504 a_12150_14850# lpopamp_core_0.sliceA_1.bna_ lpopamp_core_0.sliceA_1.bna_ avss sg13_hv_nmos ad=1.125p pd=5u as=1.125p ps=5u w=4.5u l=0.5u
X1505 lpopamp_core_0.sliceA_1.yn_m in_p lpopamp_core_0.sliceA_1.xp avdd sg13_hv_pmos ad=1.125p pd=5u as=1.125p ps=5u w=4.5u l=0.5u
X1506 avss lpopamp_core_0.sliceA_0.bna a_4050_700# avss sg13_hv_nmos ad=1.125p pd=5u as=1.125p ps=5u w=4.5u l=3.5u
X1507 lpopamp_core_0.sliceA_1.yn_m lpopamp_core_0.sliceA_1.zn_m a_27150_14850# avss sg13_hv_nmos ad=1.125p pd=5u as=1.125p ps=5u w=4.5u l=0.5u
X1508 lpopamp_core_0.sliceA_0.xn in_p a_15150_700# avss sg13_hv_nmos ad=1.125p pd=5u as=1.125p ps=5u w=4.5u l=0.5u
X1509 a_14950_100# in_p lpopamp_core_0.sliceA_0.xn avss sg13_hv_nmos ad=1.125p pd=5u as=1.125p ps=5u w=4.5u l=0.5u
X1510 lpopamp_core_0.sliceB_1.zp_m lpopamp_core_0.sliceB_1.zp_m lpopamp_core_0.sliceB_1.yp_p avdd sg13_hv_pmos ad=1.125p pd=5u as=1.125p ps=5u w=4.5u l=0.5u
X1511 avdd zp_p out avdd sg13_hv_pmos ad=1.125p pd=5u as=1.125p ps=5u w=4.5u l=0.5u
X1512 a_11950_7150# lpopamp_core_0.sliceB_0.bnb lpopamp_core_0.sliceB_0.bnb avss sg13_hv_nmos ad=1.125p pd=5u as=1.125p ps=5u w=4.5u l=0.5u
X1513 lpopamp_core_0.sliceB_1.yp_m in_p a_14150_8400# avss sg13_hv_nmos ad=1.125p pd=5u as=1.125p ps=5u w=4.5u l=0.5u
X1514 a_9150_11850# lpopamp_core_0.sliceA_1.bpa_r a_9050_11850# avdd sg13_hv_pmos ad=1.125p pd=5u as=1.125p ps=5u w=4.5u l=0.5u
X1515 lpopamp_core_0.sliceB_1.bpa_l lpopamp_core_0.sliceB_1.bpa_l a_6750_10800# avdd sg13_hv_pmos ad=1.125p pd=5u as=1.125p ps=5u w=4.5u l=0.5u
X1516 lpopamp_core_0.sliceA_0.bpb lpopamp_core_0.sliceA_0.bpb lpopamp_core_0.sliceA_0.bpa_l avdd sg13_hv_pmos ad=1.125p pd=5u as=1.125p ps=5u w=4.5u l=0.5u
X1517 zp_p en avdd avdd sg13_hv_pmos ad=1.125p pd=5u as=1.125p ps=5u w=4.5u l=1.5u
X1518 lpopamp_core_0.sliceA_1.zp_m lpopamp_core_0.sliceA_1.bnb a_20150_14250# avss sg13_hv_nmos ad=1.125p pd=5u as=1.125p ps=5u w=4.5u l=0.5u
X1519 lpopamp_core_0.sliceB_1.zn_m lpopamp_core_0.sliceB_1.bpb a_23850_10200# avdd sg13_hv_pmos ad=1.125p pd=5u as=1.125p ps=5u w=4.5u l=0.5u
X1520 a_24450_14250# lpopamp_core_0.sliceA_1.zn_m lpopamp_core_0.sliceA_1.yn_p avss sg13_hv_nmos ad=1.125p pd=5u as=1.125p ps=5u w=4.5u l=3.5u
X1521 lpopamp_core_0.sliceB_1.yp_m lpopamp_core_0.sliceB_1.zp_m zp_p avdd sg13_hv_pmos ad=1.125p pd=5u as=1.125p ps=5u w=4.5u l=0.5u
X1522 lpopamp_core_0.sliceA_0.bpa lpopamp_core_0.sliceA_0.bna a_5250_100# avss sg13_hv_nmos ad=1.125p pd=5u as=1.125p ps=5u w=4.5u l=3.5u
X1523 lpopamp_core_0.sliceB_1.xp in_p lpopamp_core_0.sliceB_1.yn_m avdd sg13_hv_pmos ad=1.125p pd=5u as=1.125p ps=5u w=4.5u l=0.5u
X1524 a_8550_8400# lpopamp_core_0.sliceB_1.bna_ a_8450_8400# avss sg13_hv_nmos ad=1.125p pd=5u as=1.125p ps=5u w=4.5u l=0.5u
X1525 lpopamp_core_0.sliceB_0.bna lpopamp_core_0.sliceB_0.bna a_2850_7150# avss sg13_hv_nmos ad=1.125p pd=5u as=1.125p ps=5u w=4.5u l=3.5u
X1526 lpopamp_core_0.sliceA_0.yp_p lpopamp_core_0.sliceA_0.zp_m avdd avdd sg13_hv_pmos ad=1.125p pd=5u as=1.125p ps=5u w=4.5u l=3.5u
X1527 a_21650_8400# lpopamp_core_0.sliceB_1.bna a_20050_7800# avss sg13_hv_nmos ad=1.125p pd=5u as=1.125p ps=5u w=4.5u l=3.5u
X1528 a_26750_7150# lpopamp_core_0.sliceB_0.bnb zn_p avss sg13_hv_nmos ad=1.125p pd=5u as=1.125p ps=5u w=4.5u l=0.5u
X1529 avdd lpopamp_core_0.sliceA_1.zp_m lpopamp_core_0.sliceA_1.yp_p avdd sg13_hv_pmos ad=1.125p pd=5u as=1.125p ps=5u w=4.5u l=3.5u
X1530 avdd en zp_p avdd sg13_hv_pmos ad=2.25p pd=10u as=1.125p ps=5u w=4.5u l=1.5u
X1531 out zn_p a_28950_8400# avss sg13_hv_nmos ad=1.125p pd=5u as=1.125p ps=5u w=4.5u l=0.5u
X1532 lpopamp_core_0.sliceA_1.bpb lpopamp_core_0.sliceA_1.bpb lpopamp_core_0.sliceA_1.bpa_r avdd sg13_hv_pmos ad=1.125p pd=5u as=1.125p ps=5u w=4.5u l=0.5u
X1533 zn_p lpopamp_core_0.sliceA_1.bpb zp_p avdd sg13_hv_pmos ad=1.125p pd=5u as=1.125p ps=5u w=4.5u l=0.5u
X1534 lpopamp_core_0.sliceA_0.bpa_r lpopamp_core_0.sliceA_0.bpb lpopamp_core_0.sliceA_0.bpb avdd sg13_hv_pmos ad=1.125p pd=5u as=1.125p ps=5u w=4.5u l=0.5u
X1535 avdd lpopamp_core_0.sliceB_0.zp_m lpopamp_core_0.sliceB_0.yp_p avdd sg13_hv_pmos ad=1.125p pd=5u as=1.125p ps=5u w=4.5u l=3.5u
X1536 lpopamp_core_0.sliceB_0.zn_m lpopamp_core_0.sliceB_0.zn_m a_23350_7150# avss sg13_hv_nmos ad=1.125p pd=5u as=1.125p ps=5u w=4.5u l=0.5u
X1537 a_7650_7150# lpopamp_core_0.sliceB_0.bna lpopamp_core_0.sliceB_0.bpb avss sg13_hv_nmos ad=1.125p pd=5u as=1.125p ps=5u w=4.5u l=3.5u
X1538 out zp_p avdd avdd sg13_hv_pmos ad=1.125p pd=5u as=1.125p ps=5u w=4.5u l=0.5u
X1539 lpopamp_core_0.sliceA_0.yn_m in_p lpopamp_core_0.sliceA_0.xp avdd sg13_hv_pmos ad=1.125p pd=5u as=1.125p ps=5u w=4.5u l=0.5u
X1540 a_12650_7800# lpopamp_core_0.sliceB_1.bna_ a_12550_7800# avss sg13_hv_nmos ad=1.125p pd=5u as=1.125p ps=5u w=4.5u l=0.5u
X1541 lpopamp_core_0.sliceA_1.yn_m in_p lpopamp_core_0.sliceA_1.xp avdd sg13_hv_pmos ad=1.125p pd=5u as=1.125p ps=5u w=4.5u l=0.5u
X1542 a_20150_7150# lpopamp_core_0.sliceB_0.bnb a_20050_6550# avss sg13_hv_nmos ad=1.125p pd=5u as=1.125p ps=5u w=4.5u l=0.5u
X1543 a_8950_14250# lpopamp_core_0.sliceA_1.bnb lpopamp_core_0.sliceA_1.bna_ avss sg13_hv_nmos ad=1.125p pd=5u as=1.125p ps=5u w=4.5u l=0.5u
X1544 lpopamp_core_0.sliceB_1.bpa_l lpopamp_core_0.sliceB_1.bpb lpopamp_core_0.sliceB_1.bpb avdd sg13_hv_pmos ad=1.125p pd=5u as=1.125p ps=5u w=4.5u l=0.5u
X1545 lpopamp_core_0.sliceB_0.yp_p lpopamp_core_0.sliceB_0.zp_m avdd avdd sg13_hv_pmos ad=1.125p pd=5u as=1.125p ps=5u w=4.5u l=3.5u
X1546 a_14750_6550# in_m lpopamp_core_0.sliceB_0.yp_p avss sg13_hv_nmos ad=1.125p pd=5u as=1.125p ps=5u w=4.5u l=0.5u
X1547 lpopamp_core_0.sliceA_0.bnb lpopamp_core_0.sliceA_0.bnb a_10550_700# avss sg13_hv_nmos ad=1.125p pd=5u as=1.125p ps=5u w=4.5u l=0.5u
X1548 a_18050_700# lpopamp_core_0.sliceA_0.zn_m avss avss sg13_hv_nmos ad=1.125p pd=5u as=1.125p ps=5u w=4.5u l=3.5u
X1549 avdd lpopamp_core_0.sliceB_0.bpa lpopamp_core_0.sliceB_0.bnb avdd sg13_hv_pmos ad=1.125p pd=5u as=1.125p ps=5u w=4.5u l=3.5u
X1550 a_23850_11850# lpopamp_core_0.sliceA_1.bpb lpopamp_core_0.sliceA_1.zn_m avdd sg13_hv_pmos ad=1.125p pd=5u as=1.125p ps=5u w=4.5u l=0.5u
X1551 avdd en lpopamp_core_0.sliceA_0.bpa avdd sg13_hv_pmos ad=1.125p pd=5u as=1.125p ps=5u w=4.5u l=1.5u
X1552 lpopamp_core_0.sliceB_0.bnb lpopamp_core_0.sliceB_0.bnb a_11350_6550# avss sg13_hv_nmos ad=1.125p pd=5u as=1.125p ps=5u w=4.5u l=0.5u
X1553 out zp_p avdd avdd sg13_hv_pmos ad=1.125p pd=5u as=1.125p ps=5u w=4.5u l=0.5u
X1554 a_10950_10800# lpopamp_core_0.sliceB_1.bpa_r lpopamp_core_0.sliceB_1.bpa_r avdd sg13_hv_pmos ad=1.125p pd=5u as=1.125p ps=5u w=4.5u l=0.5u
X1555 lpopamp_core_0.sliceA_1.yn_p in_m lpopamp_core_0.sliceA_1.xp avdd sg13_hv_pmos ad=1.125p pd=5u as=1.125p ps=5u w=4.5u l=0.5u
X1556 lpopamp_core_0.sliceB_1.bpb lpopamp_core_0.sliceB_1.bna a_6850_7800# avss sg13_hv_nmos ad=1.125p pd=5u as=1.125p ps=5u w=4.5u l=3.5u
X1557 a_11150_14850# lpopamp_core_0.sliceA_1.bnb lpopamp_core_0.sliceA_1.bnb avss sg13_hv_nmos ad=1.125p pd=5u as=1.125p ps=5u w=4.5u l=0.5u
X1558 zn_p lpopamp_core_0.sliceA_1.zn_m a_26150_14850# avss sg13_hv_nmos ad=1.125p pd=5u as=1.125p ps=5u w=4.5u l=0.5u
X1559 lpopamp_core_0.sliceA_1.bpb lpopamp_core_0.sliceA_1.bpb lpopamp_core_0.sliceA_1.bpa_r avdd sg13_hv_pmos ad=1.125p pd=5u as=1.125p ps=5u w=4.5u l=0.5u
X1560 zn_p lpopamp_core_0.sliceA_0.bnb a_26950_700# avss sg13_hv_nmos ad=1.125p pd=5u as=1.125p ps=5u w=4.5u l=0.5u
X1561 a_26750_100# lpopamp_core_0.sliceA_0.bnb zn_p avss sg13_hv_nmos ad=1.125p pd=5u as=1.125p ps=5u w=4.5u l=0.5u
X1562 out zp_p a_29850_10800# avdd sg13_hv_pmos ad=1.125p pd=5u as=1.125p ps=5u w=4.5u l=0.5u
X1563 a_9150_3100# lpopamp_core_0.sliceA_0.bpa_r a_9050_3100# avdd sg13_hv_pmos ad=1.125p pd=5u as=1.125p ps=5u w=4.5u l=0.5u
X1564 out zp_p avdd avdd sg13_hv_pmos ad=1.125p pd=5u as=1.125p ps=5u w=4.5u l=0.5u
X1565 lpopamp_core_0.sliceA_1.yp_m in_p a_14950_14850# avss sg13_hv_nmos ad=1.125p pd=5u as=1.125p ps=5u w=4.5u l=0.5u
X1566 lpopamp_core_0.sliceB_1.yn_p in_m lpopamp_core_0.sliceB_1.xp avdd sg13_hv_pmos ad=1.125p pd=5u as=1.125p ps=5u w=4.5u l=0.5u
X1567 lpopamp_core_0.sliceA_0.yp_p lpopamp_core_0.sliceA_0.zp_m lpopamp_core_0.sliceA_0.zp_m avdd sg13_hv_pmos ad=1.125p pd=5u as=1.125p ps=5u w=4.5u l=0.5u
X1568 lpopamp_core_0.sliceB_0.zn_m lpopamp_core_0.sliceB_0.bpb a_22450_4150# avdd sg13_hv_pmos ad=1.125p pd=5u as=1.125p ps=5u w=4.5u l=0.5u
X1569 zn_p lpopamp_core_0.sliceB_1.zn_m a_27350_7800# avss sg13_hv_nmos ad=1.125p pd=5u as=1.125p ps=5u w=4.5u l=0.5u
X1570 lpopamp_core_0.sliceB_0.bpa_l lpopamp_core_0.sliceB_0.bpa_l a_6750_4150# avdd sg13_hv_pmos ad=1.125p pd=5u as=1.125p ps=5u w=4.5u l=0.5u
X1571 a_6050_6550# lpopamp_core_0.sliceB_0.bna lpopamp_core_0.sliceB_0.bpa avss sg13_hv_nmos ad=1.125p pd=5u as=1.125p ps=5u w=4.5u l=3.5u
X1572 lpopamp_core_0.sliceA_0.yn_p in_m lpopamp_core_0.sliceA_0.xp avdd sg13_hv_pmos ad=1.125p pd=5u as=1.125p ps=5u w=4.5u l=0.5u
X1573 avdd lpopamp_core_0.sliceB_0.bpa a_22450_4150# avdd sg13_hv_pmos ad=1.125p pd=5u as=1.125p ps=5u w=4.5u l=3.5u
X1574 lpopamp_core_0.sliceB_0.bpa_l lpopamp_core_0.sliceB_0.bpb lpopamp_core_0.sliceB_0.bpb avdd sg13_hv_pmos ad=1.125p pd=5u as=1.125p ps=5u w=4.5u l=0.5u
X1575 a_24450_7800# lpopamp_core_0.sliceB_1.zn_m lpopamp_core_0.sliceB_1.yn_p avss sg13_hv_nmos ad=1.125p pd=5u as=1.125p ps=5u w=4.5u l=3.5u
X1576 avdd lpopamp_core_0.sliceB_0.tihi lpopamp_core_0.sliceB_0.tihi avdd sg13_hv_pmos ad=1.125p pd=5u as=1.125p ps=5u w=4.5u l=9.5u
X1577 a_29550_6550# zn_p out avss sg13_hv_nmos ad=1.125p pd=5u as=1.125p ps=5u w=4.5u l=0.5u
X1578 lpopamp_core_0.sliceA_1.enb en avss avss sg13_hv_nmos ad=1.125p pd=5u as=2.25p ps=10u w=4.5u l=1.5u
X1579 lpopamp_core_0.sliceA_1.bpb lpopamp_core_0.sliceA_1.bpb lpopamp_core_0.sliceA_1.bpa_l avdd sg13_hv_pmos ad=1.125p pd=5u as=1.125p ps=5u w=4.5u l=0.5u
X1580 a_8150_700# lpopamp_core_0.sliceA_0.bna_ avss avss sg13_hv_nmos ad=1.125p pd=5u as=1.125p ps=5u w=4.5u l=0.5u
X1581 zp_p lpopamp_core_0.sliceB_0.zp_m lpopamp_core_0.sliceB_0.yp_m avdd sg13_hv_pmos ad=1.125p pd=5u as=1.125p ps=5u w=4.5u l=0.5u
X1582 a_12150_700# lpopamp_core_0.sliceA_0.bna_ lpopamp_core_0.sliceA_0.bna_ avss sg13_hv_nmos ad=1.125p pd=5u as=1.125p ps=5u w=4.5u l=0.5u
X1583 lpopamp_core_0.sliceA_0.bnb lpopamp_core_0.sliceA_0.bnb a_11750_100# avss sg13_hv_nmos ad=1.125p pd=5u as=1.125p ps=5u w=4.5u l=0.5u
X1584 avss lpopamp_core_0.sliceA_0.zn_m a_18850_100# avss sg13_hv_nmos ad=1.125p pd=5u as=1.125p ps=5u w=4.5u l=3.5u
X1585 zn_p lpopamp_core_0.sliceB_0.zn_m a_26150_6550# avss sg13_hv_nmos ad=1.125p pd=5u as=1.125p ps=5u w=4.5u l=0.5u
X1586 lpopamp_core_0.sliceB_1.bpb lpopamp_core_0.sliceB_1.bpb lpopamp_core_0.sliceB_1.bpa_r avdd sg13_hv_pmos ad=1.125p pd=5u as=1.125p ps=5u w=4.5u l=0.5u
X1587 a_20950_700# lpopamp_core_0.sliceA_0.bnb a_20050_100# avss sg13_hv_nmos ad=1.125p pd=5u as=1.125p ps=5u w=4.5u l=0.5u
X1588 a_23850_4150# lpopamp_core_0.sliceB_0.bpb lpopamp_core_0.sliceB_0.zn_m avdd sg13_hv_pmos ad=1.125p pd=5u as=1.125p ps=5u w=4.5u l=0.5u
X1589 lpopamp_core_0.sliceB_1.zn_m lpopamp_core_0.sliceB_1.bpb a_22450_10200# avdd sg13_hv_pmos ad=1.125p pd=5u as=1.125p ps=5u w=4.5u l=0.5u
X1590 a_23150_14250# lpopamp_core_0.sliceA_1.zn_m lpopamp_core_0.sliceA_1.zn_m avss sg13_hv_nmos ad=1.125p pd=5u as=1.125p ps=5u w=4.5u l=0.5u
X1591 avdd lpopamp_core_0.sliceB_1.bpa lpopamp_core_0.sliceB_1.bnb avdd sg13_hv_pmos ad=1.125p pd=5u as=1.125p ps=5u w=4.5u l=3.5u
X1592 a_21150_100# lpopamp_core_0.sliceA_0.bnb lpopamp_core_0.sliceA_0.zp_m avss sg13_hv_nmos ad=1.125p pd=5u as=1.125p ps=5u w=4.5u l=0.5u
X1593 lpopamp_core_0.sliceB_1.yp_p in_m a_14550_8400# avss sg13_hv_nmos ad=1.125p pd=5u as=1.125p ps=5u w=4.5u l=0.5u
X1594 a_17250_14250# lpopamp_core_0.sliceA_1.zn_m lpopamp_core_0.sliceA_1.yn_p avss sg13_hv_nmos ad=1.125p pd=5u as=1.125p ps=5u w=4.5u l=3.5u
X1595 zn_p lpopamp_core_0.sliceA_1.bnb a_26950_14250# avss sg13_hv_nmos ad=1.125p pd=5u as=1.125p ps=5u w=4.5u l=0.5u
X1596 a_11350_8400# lpopamp_core_0.sliceB_1.bnb lpopamp_core_0.sliceB_1.bna_ avss sg13_hv_nmos ad=1.125p pd=5u as=1.125p ps=5u w=4.5u l=0.5u
X1597 lpopamp_core_0.sliceA_0.bpb lpopamp_core_0.sliceA_0.bpb lpopamp_core_0.sliceA_0.bpa_l avdd sg13_hv_pmos ad=1.125p pd=5u as=1.125p ps=5u w=4.5u l=0.5u
X1598 lpopamp_core_0.sliceA_1.yp_p lpopamp_core_0.sliceA_1.zp_m avdd avdd sg13_hv_pmos ad=1.125p pd=5u as=1.125p ps=5u w=4.5u l=3.5u
X1599 avdd lpopamp_core_0.sliceA_0.zp_m lpopamp_core_0.sliceA_0.yp_p avdd sg13_hv_pmos ad=1.125p pd=5u as=1.125p ps=5u w=4.5u l=3.5u
X1600 lpopamp_core_0.sliceA_0.yp_m lpopamp_core_0.sliceA_0.zp_m zp_p avdd sg13_hv_pmos ad=1.125p pd=5u as=1.125p ps=5u w=4.5u l=0.5u
X1601 out zp_p avdd avdd sg13_hv_pmos ad=1.125p pd=5u as=1.125p ps=5u w=4.5u l=0.5u
X1602 a_9350_100# lpopamp_core_0.sliceA_0.bnb lpopamp_core_0.sliceA_0.bna_ avss sg13_hv_nmos ad=1.125p pd=5u as=1.125p ps=5u w=4.5u l=0.5u
X1603 avss zn_p a_29950_6550# avss sg13_hv_nmos ad=1.125p pd=5u as=1.125p ps=5u w=4.5u l=0.5u
X1604 avdd lpopamp_core_0.sliceA_1.bpa lpopamp_core_0.sliceA_1.xp avdd sg13_hv_pmos ad=1.125p pd=5u as=1.125p ps=5u w=4.5u l=3.5u
X1605 a_6650_10200# lpopamp_core_0.sliceB_1.bpa_l a_6550_10200# avdd sg13_hv_pmos ad=1.125p pd=5u as=1.125p ps=5u w=4.5u l=0.5u
X1606 a_8950_8400# lpopamp_core_0.sliceB_1.bnb lpopamp_core_0.sliceB_1.bna_ avss sg13_hv_nmos ad=1.125p pd=5u as=1.125p ps=5u w=4.5u l=0.5u
X1607 lpopamp_core_0.sliceA_0.xn lpopamp_core_0.sliceA_0.bna a_13250_100# avss sg13_hv_nmos ad=1.125p pd=5u as=1.125p ps=5u w=4.5u l=3.5u
X1608 a_10150_7150# lpopamp_core_0.sliceB_0.bnb lpopamp_core_0.sliceB_0.bna_ avss sg13_hv_nmos ad=1.125p pd=5u as=1.125p ps=5u w=4.5u l=0.5u
X1609 avss lpopamp_core_0.sliceB_1.bna a_21650_8400# avss sg13_hv_nmos ad=1.125p pd=5u as=1.125p ps=5u w=4.5u l=3.5u
X1610 a_29550_700# zn_p out avss sg13_hv_nmos ad=1.125p pd=5u as=1.125p ps=5u w=4.5u l=0.5u
X1611 out zn_p a_29350_8400# avss sg13_hv_nmos ad=1.125p pd=5u as=1.125p ps=5u w=4.5u l=0.5u
X1612 avss en lpopamp_core_0.sliceB_1.enb avss sg13_hv_nmos ad=1.125p pd=5u as=1.125p ps=5u w=4.5u l=1.5u
X1613 lpopamp_core_0.sliceA_0.bpa_r lpopamp_core_0.sliceA_0.bpb lpopamp_core_0.sliceA_0.bpb avdd sg13_hv_pmos ad=1.125p pd=5u as=1.125p ps=5u w=4.5u l=0.5u
X1614 lpopamp_core_0.sliceB_0.zn_m lpopamp_core_0.sliceB_0.zn_m a_23750_7150# avss sg13_hv_nmos ad=1.125p pd=5u as=1.125p ps=5u w=4.5u l=0.5u
X1615 avss lpopamp_core_0.sliceB_0.bna a_7650_7150# avss sg13_hv_nmos ad=1.125p pd=5u as=1.125p ps=5u w=4.5u l=3.5u
X1616 lpopamp_core_0.sliceB_1.yp_p lpopamp_core_0.sliceB_1.zp_m lpopamp_core_0.sliceB_1.zp_m avdd sg13_hv_pmos ad=1.125p pd=5u as=1.125p ps=5u w=4.5u l=0.5u
X1617 lpopamp_core_0.sliceA_0.yn_m in_p lpopamp_core_0.sliceA_0.xp avdd sg13_hv_pmos ad=1.125p pd=5u as=1.125p ps=5u w=4.5u l=0.5u
X1618 a_26150_8400# lpopamp_core_0.sliceB_1.zn_m lpopamp_core_0.sliceB_1.yn_m avss sg13_hv_nmos ad=1.125p pd=5u as=1.125p ps=5u w=4.5u l=0.5u
X1619 a_21650_14850# lpopamp_core_0.sliceA_1.bna a_20050_14250# avss sg13_hv_nmos ad=1.125p pd=5u as=1.125p ps=5u w=4.5u l=3.5u
X1620 zp_p lpopamp_core_0.sliceA_1.zp_m lpopamp_core_0.sliceA_1.yp_m avdd sg13_hv_pmos ad=1.125p pd=5u as=1.125p ps=5u w=4.5u l=0.5u
X1621 a_10150_14850# lpopamp_core_0.sliceA_1.bnb lpopamp_core_0.sliceA_1.bna_ avss sg13_hv_nmos ad=1.125p pd=5u as=1.125p ps=5u w=4.5u l=0.5u
X1622 lpopamp_core_0.sliceA_1.xp lpopamp_core_0.sliceA_1.bpa avdd avdd sg13_hv_pmos ad=1.125p pd=5u as=1.125p ps=5u w=4.5u l=3.5u
X1623 a_20550_7150# lpopamp_core_0.sliceB_0.bnb a_20050_6550# avss sg13_hv_nmos ad=1.125p pd=5u as=1.125p ps=5u w=4.5u l=0.5u
X1624 lpopamp_core_0.sliceA_1.bpb lpopamp_core_0.sliceA_1.bpb lpopamp_core_0.sliceA_1.bpa_l avdd sg13_hv_pmos ad=1.125p pd=5u as=1.125p ps=5u w=4.5u l=0.5u
X1625 out zp_p avdd avdd sg13_hv_pmos ad=1.125p pd=5u as=1.125p ps=5u w=4.5u l=0.5u
X1626 lpopamp_core_0.sliceB_0.zp_m lpopamp_core_0.sliceB_0.zp_m lpopamp_core_0.sliceB_0.yp_p avdd sg13_hv_pmos ad=1.125p pd=5u as=1.125p ps=5u w=4.5u l=0.5u
X1627 lpopamp_core_0.sliceA_1.xn in_m a_13950_14850# avss sg13_hv_nmos ad=1.125p pd=5u as=1.125p ps=5u w=4.5u l=0.5u
X1628 a_29150_14850# zn_p out avss sg13_hv_nmos ad=1.125p pd=5u as=1.125p ps=5u w=4.5u l=0.5u
X1629 lpopamp_core_0.sliceB_1.xp lpopamp_core_0.sliceB_1.bpa avdd avdd sg13_hv_pmos ad=1.125p pd=5u as=1.125p ps=5u w=4.5u l=3.5u
X1630 lpopamp_core_0.sliceA_0.bna en ib avss sg13_hv_nmos ad=1.125p pd=5u as=1.125p ps=5u w=4.5u l=1.5u
X1631 lpopamp_core_0.sliceA_0.yp_m in_p a_14550_700# avss sg13_hv_nmos ad=1.125p pd=5u as=1.125p ps=5u w=4.5u l=0.5u
X1632 lpopamp_core_0.sliceB_0.yp_m lpopamp_core_0.sliceB_0.bpa avdd avdd sg13_hv_pmos ad=1.125p pd=5u as=1.125p ps=5u w=4.5u l=3.5u
X1633 lpopamp_core_0.sliceB_0.bnb lpopamp_core_0.sliceB_0.bnb a_11750_6550# avss sg13_hv_nmos ad=1.125p pd=5u as=1.125p ps=5u w=4.5u l=0.5u
X1634 out zp_p avdd avdd sg13_hv_pmos ad=1.125p pd=5u as=1.125p ps=5u w=4.5u l=0.5u
X1635 a_14150_7800# in_p lpopamp_core_0.sliceB_1.xn avss sg13_hv_nmos ad=1.125p pd=5u as=1.125p ps=5u w=4.5u l=0.5u
X1636 lpopamp_core_0.sliceA_0.yn_p lpopamp_core_0.sliceA_0.zn_m a_23550_100# avss sg13_hv_nmos ad=1.125p pd=5u as=1.125p ps=5u w=4.5u l=0.5u
X1637 lpopamp_core_0.sliceA_1.bpb lpopamp_core_0.sliceA_1.bpb lpopamp_core_0.sliceA_1.bpa_l avdd sg13_hv_pmos ad=1.125p pd=5u as=1.125p ps=5u w=4.5u l=0.5u
X1638 zn_p lpopamp_core_0.sliceA_0.bpb zp_p avdd sg13_hv_pmos ad=1.125p pd=5u as=1.125p ps=5u w=4.5u l=0.5u
X1639 avdd lpopamp_core_0.sliceB_0.bpa lpopamp_core_0.sliceB_0.xp avdd sg13_hv_pmos ad=1.125p pd=5u as=1.125p ps=5u w=4.5u l=3.5u
X1640 lpopamp_core_0.sliceA_0.bpb lpopamp_core_0.sliceA_0.bpb lpopamp_core_0.sliceA_0.bpa_r avdd sg13_hv_pmos ad=1.125p pd=5u as=1.125p ps=5u w=4.5u l=0.5u
X1641 a_8750_10800# lpopamp_core_0.sliceB_1.bpa_l a_8650_10800# avdd sg13_hv_pmos ad=1.125p pd=5u as=1.125p ps=5u w=4.5u l=0.5u
X1642 a_22450_14250# lpopamp_core_0.sliceA_1.zn_m avss avss sg13_hv_nmos ad=1.125p pd=5u as=1.125p ps=5u w=4.5u l=3.5u
X1643 lpopamp_core_0.sliceB_1.bpb lpopamp_core_0.sliceB_1.bpb lpopamp_core_0.sliceB_1.bpa_r avdd sg13_hv_pmos ad=1.125p pd=5u as=1.125p ps=5u w=4.5u l=0.5u
X1644 lpopamp_core_0.sliceA_0.yn_p in_m lpopamp_core_0.sliceA_0.xp avdd sg13_hv_pmos ad=1.125p pd=5u as=1.125p ps=5u w=4.5u l=0.5u
X1645 a_23850_4150# lpopamp_core_0.sliceB_0.bpa avdd avdd sg13_hv_pmos ad=1.125p pd=5u as=1.125p ps=5u w=4.5u l=3.5u
X1646 zn_p lpopamp_core_0.sliceB_1.bpb zp_p avdd sg13_hv_pmos ad=1.125p pd=5u as=1.125p ps=5u w=4.5u l=0.5u
X1647 lpopamp_core_0.sliceB_0.bpa_l lpopamp_core_0.sliceB_0.bpb lpopamp_core_0.sliceB_0.bpb avdd sg13_hv_pmos ad=1.125p pd=5u as=1.125p ps=5u w=4.5u l=0.5u
X1648 a_29950_6550# zn_p out avss sg13_hv_nmos ad=1.125p pd=5u as=1.125p ps=5u w=4.5u l=0.5u
X1649 avss lpopamp_core_0.sliceB_1.zn_m a_24450_7800# avss sg13_hv_nmos ad=1.125p pd=5u as=1.125p ps=5u w=4.5u l=3.5u
X1650 a_8450_7800# lpopamp_core_0.sliceB_1.bna_ a_8350_7800# avss sg13_hv_nmos ad=1.125p pd=5u as=1.125p ps=5u w=4.5u l=0.5u
X1651 lpopamp_core_0.sliceA_1.yn_m lpopamp_core_0.sliceA_1.zn_m a_25950_14250# avss sg13_hv_nmos ad=1.125p pd=5u as=1.125p ps=5u w=4.5u l=0.5u
X1652 out zp_p avdd avdd sg13_hv_pmos ad=1.125p pd=5u as=1.125p ps=5u w=4.5u l=0.5u
X1653 avss lpopamp_core_0.sliceA_0.enb lpopamp_core_0.sliceA_0.bna avss sg13_hv_nmos ad=1.125p pd=5u as=1.125p ps=5u w=4.5u l=1.5u
X1654 zp_p lpopamp_core_0.sliceB_0.bpb zn_p avdd sg13_hv_pmos ad=1.125p pd=5u as=1.125p ps=5u w=4.5u l=0.5u
X1655 lpopamp_core_0.sliceB_0.yp_p lpopamp_core_0.sliceB_0.zp_m lpopamp_core_0.sliceB_0.zp_m avdd sg13_hv_pmos ad=1.125p pd=5u as=1.125p ps=5u w=4.5u l=0.5u
X1656 a_20050_7800# lpopamp_core_0.sliceB_1.bnb a_21150_7800# avss sg13_hv_nmos ad=1.125p pd=5u as=1.125p ps=5u w=4.5u l=0.5u
X1657 lpopamp_core_0.sliceB_1.yn_p in_m lpopamp_core_0.sliceB_1.xp avdd sg13_hv_pmos ad=1.125p pd=5u as=1.125p ps=5u w=4.5u l=0.5u
X1658 a_16450_700# lpopamp_core_0.sliceA_0.zn_m avss avss sg13_hv_nmos ad=1.125p pd=5u as=1.125p ps=5u w=4.5u l=3.5u
X1659 zn_p lpopamp_core_0.sliceB_0.bnb a_26550_6550# avss sg13_hv_nmos ad=1.125p pd=5u as=1.125p ps=5u w=4.5u l=0.5u
X1660 a_23850_4150# lpopamp_core_0.sliceB_0.bpb lpopamp_core_0.sliceB_0.zn_m avdd sg13_hv_pmos ad=1.125p pd=5u as=1.125p ps=5u w=4.5u l=0.5u
X1661 a_25250_700# lpopamp_core_0.sliceA_0.zn_m avss avss sg13_hv_nmos ad=1.125p pd=5u as=1.125p ps=5u w=4.5u l=3.5u
X1662 lpopamp_core_0.sliceA_0.bpb lpopamp_core_0.sliceA_0.bpb lpopamp_core_0.sliceA_0.bpa_r avdd sg13_hv_pmos ad=1.125p pd=5u as=1.125p ps=5u w=4.5u l=0.5u
X1663 lpopamp_core_0.sliceB_0.bpb lpopamp_core_0.sliceB_0.bpb lpopamp_core_0.sliceB_0.bpa_l avdd sg13_hv_pmos ad=1.125p pd=5u as=1.125p ps=5u w=4.5u l=0.5u
X1664 a_23350_6550# lpopamp_core_0.sliceB_0.zn_m lpopamp_core_0.sliceB_0.yn_p avss sg13_hv_nmos ad=1.125p pd=5u as=1.125p ps=5u w=4.5u l=0.5u
X1665 lpopamp_core_0.sliceB_0.zp_m lpopamp_core_0.sliceB_0.zp_m lpopamp_core_0.sliceB_0.yp_p avdd sg13_hv_pmos ad=1.125p pd=5u as=1.125p ps=5u w=4.5u l=0.5u
X1666 zp_p lpopamp_core_0.sliceA_1.bpb zn_p avdd sg13_hv_pmos ad=1.125p pd=5u as=1.125p ps=5u w=4.5u l=0.5u
X1667 lpopamp_core_0.sliceA_1.bpb lpopamp_core_0.sliceA_1.bna a_6850_14250# avss sg13_hv_nmos ad=1.125p pd=5u as=1.125p ps=5u w=4.5u l=3.5u
X1668 lpopamp_core_0.sliceA_0.bpb lpopamp_core_0.sliceA_0.bpb lpopamp_core_0.sliceA_0.bpa_l avdd sg13_hv_pmos ad=1.125p pd=5u as=1.125p ps=5u w=4.5u l=0.5u
X1669 lpopamp_core_0.sliceB_1.bpb lpopamp_core_0.sliceB_1.bpb lpopamp_core_0.sliceB_1.bpa_r avdd sg13_hv_pmos ad=1.125p pd=5u as=1.125p ps=5u w=4.5u l=0.5u
X1670 a_11750_8400# lpopamp_core_0.sliceB_1.bnb lpopamp_core_0.sliceB_1.bna_ avss sg13_hv_nmos ad=1.125p pd=5u as=1.125p ps=5u w=4.5u l=0.5u
X1671 lpopamp_core_0.sliceA_0.yp_p lpopamp_core_0.sliceA_0.zp_m avdd avdd sg13_hv_pmos ad=1.125p pd=5u as=1.125p ps=5u w=4.5u l=3.5u
X1672 lpopamp_core_0.sliceB_0.yp_m in_p a_13750_7150# avss sg13_hv_nmos ad=1.125p pd=5u as=1.125p ps=5u w=4.5u l=0.5u
X1673 avdd lpopamp_core_0.sliceA_1.bpa_r a_11150_11850# avdd sg13_hv_pmos ad=1.125p pd=5u as=1.125p ps=5u w=4.5u l=0.5u
X1674 a_16450_8400# lpopamp_core_0.sliceB_1.zn_m avss avss sg13_hv_nmos ad=1.125p pd=5u as=1.125p ps=5u w=4.5u l=3.5u
X1675 a_20350_14850# lpopamp_core_0.sliceA_1.bnb lpopamp_core_0.sliceA_1.zp_m avss sg13_hv_nmos ad=1.125p pd=5u as=1.125p ps=5u w=4.5u l=0.5u
X1676 avdd lpopamp_core_0.sliceA_1.zp_m lpopamp_core_0.sliceA_1.yp_m avdd sg13_hv_pmos ad=1.125p pd=5u as=1.125p ps=5u w=4.5u l=3.5u
X1677 avss lpopamp_core_0.sliceA_0.zn_m a_17250_100# avss sg13_hv_nmos ad=1.125p pd=5u as=1.125p ps=5u w=4.5u l=3.5u
X1678 a_10550_7150# lpopamp_core_0.sliceB_0.bnb lpopamp_core_0.sliceB_0.bna_ avss sg13_hv_nmos ad=1.125p pd=5u as=1.125p ps=5u w=4.5u l=0.5u
X1679 lpopamp_core_0.sliceA_1.bpb lpopamp_core_0.sliceA_1.bpb lpopamp_core_0.sliceA_1.bpa_l avdd sg13_hv_pmos ad=1.125p pd=5u as=1.125p ps=5u w=4.5u l=0.5u
X1680 lpopamp_core_0.sliceA_0.bnb lpopamp_core_0.sliceA_0.bnb a_10150_100# avss sg13_hv_nmos ad=1.125p pd=5u as=1.125p ps=5u w=4.5u l=0.5u
X1681 a_9050_2500# lpopamp_core_0.sliceA_0.bpa_r a_8950_2500# avdd sg13_hv_pmos ad=1.125p pd=5u as=1.125p ps=5u w=4.5u l=0.5u
X1682 zp_p lpopamp_core_0.sliceB_1.zp_m lpopamp_core_0.sliceB_1.yp_m avdd sg13_hv_pmos ad=1.125p pd=5u as=1.125p ps=5u w=4.5u l=0.5u
X1683 zp_p lpopamp_core_0.sliceA_0.bnb a_26350_700# avss sg13_hv_nmos ad=1.125p pd=5u as=1.125p ps=5u w=4.5u l=0.5u
X1684 avss lpopamp_core_0.sliceA_1.zn_m a_28050_14850# avss sg13_hv_nmos ad=1.125p pd=5u as=1.125p ps=5u w=4.5u l=3.5u
X1685 lpopamp_core_0.sliceB_1.yn_m in_p lpopamp_core_0.sliceB_1.xp avdd sg13_hv_pmos ad=1.125p pd=5u as=1.125p ps=5u w=4.5u l=0.5u
X1686 out zn_p a_29750_8400# avss sg13_hv_nmos ad=1.125p pd=5u as=1.125p ps=5u w=4.5u l=0.5u
X1687 avdd lpopamp_core_0.sliceA_0.bpa lpopamp_core_0.sliceA_0.xp avdd sg13_hv_pmos ad=1.125p pd=5u as=1.125p ps=5u w=4.5u l=3.5u
X1688 a_26550_8400# lpopamp_core_0.sliceB_1.bnb zp_p avss sg13_hv_nmos ad=1.125p pd=5u as=1.125p ps=5u w=4.5u l=0.5u
X1689 avdd lpopamp_core_0.sliceA_1.bpa lpopamp_core_0.sliceA_1.bpa avdd sg13_hv_pmos ad=1.125p pd=5u as=1.125p ps=5u w=4.5u l=3.5u
X1690 a_20950_7150# lpopamp_core_0.sliceB_0.bnb a_20050_6550# avss sg13_hv_nmos ad=1.125p pd=5u as=1.125p ps=5u w=4.5u l=0.5u
X1691 lpopamp_core_0.sliceB_1.yn_p lpopamp_core_0.sliceB_1.zn_m a_23150_8400# avss sg13_hv_nmos ad=1.125p pd=5u as=1.125p ps=5u w=4.5u l=0.5u
X1692 out zn_p a_28550_7150# avss sg13_hv_nmos ad=1.125p pd=5u as=1.125p ps=5u w=4.5u l=0.5u
X1693 lpopamp_core_0.sliceB_1.bpb lpopamp_core_0.sliceB_1.bpb lpopamp_core_0.sliceB_1.bpa_l avdd sg13_hv_pmos ad=1.125p pd=5u as=1.125p ps=5u w=4.5u l=0.5u
X1694 a_11550_700# lpopamp_core_0.sliceA_0.bnb lpopamp_core_0.sliceA_0.bnb avss sg13_hv_nmos ad=1.125p pd=5u as=1.125p ps=5u w=4.5u l=0.5u
X1695 lpopamp_core_0.sliceB_0.xp in_p lpopamp_core_0.sliceB_0.yn_m avdd sg13_hv_pmos ad=1.125p pd=5u as=1.125p ps=5u w=4.5u l=0.5u
X1696 lpopamp_core_0.sliceB_0.yn_m lpopamp_core_0.sliceB_0.zn_m a_25250_7150# avss sg13_hv_nmos ad=1.125p pd=5u as=1.125p ps=5u w=4.5u l=3.5u
X1697 lpopamp_core_0.sliceB_0.bna_ lpopamp_core_0.sliceB_0.bnb a_9150_7150# avss sg13_hv_nmos ad=1.125p pd=5u as=1.125p ps=5u w=4.5u l=0.5u
X1698 a_21150_14250# lpopamp_core_0.sliceA_1.bnb lpopamp_core_0.sliceA_1.zp_m avss sg13_hv_nmos ad=1.125p pd=5u as=1.125p ps=5u w=4.5u l=0.5u
X1699 a_14550_7800# in_m lpopamp_core_0.sliceB_1.xn avss sg13_hv_nmos ad=1.125p pd=5u as=1.125p ps=5u w=4.5u l=0.5u
X1700 a_14950_14250# in_p lpopamp_core_0.sliceA_1.xn avss sg13_hv_nmos ad=1.125p pd=5u as=1.125p ps=5u w=4.5u l=0.5u
X1701 out zp_p avdd avdd sg13_hv_pmos ad=1.125p pd=5u as=1.125p ps=5u w=4.5u l=0.5u
X1702 lpopamp_core_0.sliceA_0.yn_m lpopamp_core_0.sliceA_0.zn_m a_27550_100# avss sg13_hv_nmos ad=1.125p pd=5u as=1.125p ps=5u w=4.5u l=0.5u
X1703 a_20550_100# lpopamp_core_0.sliceA_0.bnb a_20050_100# avss sg13_hv_nmos ad=1.125p pd=5u as=1.125p ps=5u w=4.5u l=0.5u
X1704 lpopamp_core_0.sliceB_0.xp lpopamp_core_0.sliceB_0.bpa avdd avdd sg13_hv_pmos ad=1.125p pd=5u as=1.125p ps=5u w=4.5u l=3.5u
X1705 lpopamp_core_0.sliceA_0.bpb lpopamp_core_0.sliceA_0.bpb lpopamp_core_0.sliceA_0.bpa_r avdd sg13_hv_pmos ad=1.125p pd=5u as=1.125p ps=5u w=4.5u l=0.5u
X1706 lpopamp_core_0.sliceB_0.bpa_r lpopamp_core_0.sliceB_0.bpb lpopamp_core_0.sliceB_0.bpb avdd sg13_hv_pmos ad=1.125p pd=5u as=1.125p ps=5u w=4.5u l=0.5u
X1707 lpopamp_core_0.sliceB_1.bna_ lpopamp_core_0.sliceB_1.bnb a_11150_7800# avss sg13_hv_nmos ad=1.125p pd=5u as=1.125p ps=5u w=4.5u l=0.5u
X1708 lpopamp_core_0.sliceA_0.zn_m lpopamp_core_0.sliceA_0.bpb a_22450_2500# avdd sg13_hv_pmos ad=1.125p pd=5u as=1.125p ps=5u w=4.5u l=0.5u
X1709 a_6650_3100# lpopamp_core_0.sliceA_0.bpa_l a_6550_3100# avdd sg13_hv_pmos ad=1.125p pd=5u as=1.125p ps=5u w=4.5u l=0.5u
X1710 avss lpopamp_core_0.sliceB_1.enb zn_p avss sg13_hv_nmos ad=2.25p pd=10u as=1.125p ps=5u w=4.5u l=1.5u
X1711 a_22450_11850# lpopamp_core_0.sliceA_1.bpb lpopamp_core_0.sliceA_1.zn_m avdd sg13_hv_pmos ad=1.125p pd=5u as=1.125p ps=5u w=4.5u l=0.5u
X1712 lpopamp_core_0.sliceB_0.xn lpopamp_core_0.sliceB_0.bna a_13250_6550# avss sg13_hv_nmos ad=1.125p pd=5u as=1.125p ps=5u w=4.5u l=3.5u
X1713 a_11150_4150# lpopamp_core_0.sliceB_0.bpa_r a_11050_4150# avdd sg13_hv_pmos ad=1.125p pd=5u as=1.125p ps=5u w=4.5u l=0.5u
X1714 lpopamp_core_0.sliceB_0.zn_m lpopamp_core_0.sliceB_0.bpb a_23850_4150# avdd sg13_hv_pmos ad=1.125p pd=5u as=1.125p ps=5u w=4.5u l=0.5u
X1715 lpopamp_core_0.sliceB_0.bpa_l lpopamp_core_0.sliceB_0.bpb lpopamp_core_0.sliceB_0.bpb avdd sg13_hv_pmos ad=1.125p pd=5u as=1.125p ps=5u w=4.5u l=0.5u
X1716 a_25250_7800# lpopamp_core_0.sliceB_1.zn_m avss avss sg13_hv_nmos ad=1.125p pd=5u as=1.125p ps=5u w=4.5u l=3.5u
X1717 lpopamp_core_0.sliceB_1.bna_ lpopamp_core_0.sliceB_1.bna_ a_8750_7800# avss sg13_hv_nmos ad=1.125p pd=5u as=1.125p ps=5u w=4.5u l=0.5u
X1718 lpopamp_core_0.sliceB_0.bna_ lpopamp_core_0.sliceB_0.bnb a_9950_6550# avss sg13_hv_nmos ad=1.125p pd=5u as=1.125p ps=5u w=4.5u l=0.5u
X1719 lpopamp_core_0.sliceA_1.yp_m lpopamp_core_0.sliceA_1.zp_m avdd avdd sg13_hv_pmos ad=1.125p pd=5u as=1.125p ps=5u w=4.5u l=3.5u
X1720 zp_p lpopamp_core_0.sliceA_0.zp_m lpopamp_core_0.sliceA_0.yp_m avdd sg13_hv_pmos ad=1.125p pd=5u as=1.125p ps=5u w=4.5u l=0.5u
X1721 lpopamp_core_0.sliceA_0.bnb lpopamp_core_0.sliceA_0.bnb a_8950_700# avss sg13_hv_nmos ad=1.125p pd=5u as=1.125p ps=5u w=4.5u l=0.5u
X1722 a_8750_100# lpopamp_core_0.sliceA_0.bna_ a_8650_100# avss sg13_hv_nmos ad=1.125p pd=5u as=1.125p ps=5u w=4.5u l=0.5u
X1723 a_12750_100# lpopamp_core_0.sliceA_0.bna_ a_12650_100# avss sg13_hv_nmos ad=1.125p pd=5u as=1.125p ps=5u w=4.5u l=0.5u
X1724 lpopamp_core_0.sliceB_0.bpa en avdd avdd sg13_hv_pmos ad=1.125p pd=5u as=1.125p ps=5u w=4.5u l=1.5u
X1725 a_8550_10200# lpopamp_core_0.sliceB_1.bpa_l lpopamp_core_0.sliceB_1.bpa_l avdd sg13_hv_pmos ad=1.125p pd=5u as=1.125p ps=5u w=4.5u l=0.5u
X1726 lpopamp_core_0.sliceA_1.bnb lpopamp_core_0.sliceA_1.bnb a_9750_14250# avss sg13_hv_nmos ad=1.125p pd=5u as=1.125p ps=5u w=4.5u l=0.5u
X1727 a_29350_7800# zn_p avss avss sg13_hv_nmos ad=1.125p pd=5u as=1.125p ps=5u w=4.5u l=0.5u
X1728 a_28950_700# zn_p avss avss sg13_hv_nmos ad=1.125p pd=5u as=1.125p ps=5u w=4.5u l=0.5u
X1729 lpopamp_core_0.sliceA_0.bpb lpopamp_core_0.sliceA_0.bpb lpopamp_core_0.sliceA_0.bpa_r avdd sg13_hv_pmos ad=1.125p pd=5u as=1.125p ps=5u w=4.5u l=0.5u
X1730 a_8750_4150# lpopamp_core_0.sliceB_0.bpa_l a_8650_4150# avdd sg13_hv_pmos ad=1.125p pd=5u as=1.125p ps=5u w=4.5u l=0.5u
X1731 a_23750_6550# lpopamp_core_0.sliceB_0.zn_m lpopamp_core_0.sliceB_0.yn_p avss sg13_hv_nmos ad=1.125p pd=5u as=1.125p ps=5u w=4.5u l=0.5u
X1732 lpopamp_core_0.sliceA_1.yp_p lpopamp_core_0.sliceA_1.zp_m lpopamp_core_0.sliceA_1.zp_m avdd sg13_hv_pmos ad=1.125p pd=5u as=1.125p ps=5u w=4.5u l=0.5u
X1733 lpopamp_core_0.sliceA_0.xp in_p lpopamp_core_0.sliceA_0.yn_m avdd sg13_hv_pmos ad=1.125p pd=5u as=1.125p ps=5u w=4.5u l=0.5u
X1734 lpopamp_core_0.sliceB_0.zp_m lpopamp_core_0.sliceB_0.zp_m lpopamp_core_0.sliceB_0.yp_p avdd sg13_hv_pmos ad=1.125p pd=5u as=1.125p ps=5u w=4.5u l=0.5u
X1735 lpopamp_core_0.sliceB_1.yn_m lpopamp_core_0.sliceB_1.zn_m a_25950_7800# avss sg13_hv_nmos ad=1.125p pd=5u as=1.125p ps=5u w=4.5u l=0.5u
X1736 lpopamp_core_0.sliceA_1.bpa_r lpopamp_core_0.sliceA_1.bpb lpopamp_core_0.sliceA_1.bpb avdd sg13_hv_pmos ad=1.125p pd=5u as=1.125p ps=5u w=4.5u l=0.5u
X1737 a_29150_100# zn_p out avss sg13_hv_nmos ad=1.125p pd=5u as=1.125p ps=5u w=4.5u l=0.5u
X1738 zp_p lpopamp_core_0.sliceA_1.zp_m lpopamp_core_0.sliceA_1.yp_m avdd sg13_hv_pmos ad=1.125p pd=5u as=1.125p ps=5u w=4.5u l=0.5u
X1739 a_20050_6550# lpopamp_core_0.sliceB_0.bnb a_20350_6550# avss sg13_hv_nmos ad=1.125p pd=5u as=1.125p ps=5u w=4.5u l=0.5u
X1740 avdd lpopamp_core_0.sliceA_1.zp_m lpopamp_core_0.sliceA_1.yp_p avdd sg13_hv_pmos ad=1.125p pd=5u as=1.125p ps=5u w=4.5u l=3.5u
X1741 avdd zp_p out avdd sg13_hv_pmos ad=1.125p pd=5u as=1.125p ps=5u w=4.5u l=0.5u
X1742 lpopamp_core_0.sliceA_1.yn_p lpopamp_core_0.sliceA_1.zn_m a_23150_14850# avss sg13_hv_nmos ad=1.125p pd=5u as=1.125p ps=5u w=4.5u l=0.5u
X1743 avdd zp_p out avdd sg13_hv_pmos ad=1.125p pd=5u as=1.125p ps=5u w=4.5u l=0.5u
X1744 lpopamp_core_0.sliceB_0.enb en avdd avdd sg13_hv_pmos ad=1.125p pd=5u as=2.25p ps=10u w=4.5u l=1.5u
X1745 avss lpopamp_core_0.sliceB_0.zn_m a_28050_6550# avss sg13_hv_nmos ad=1.125p pd=5u as=1.125p ps=5u w=4.5u l=3.5u
X1746 lpopamp_core_0.sliceA_1.bna_ lpopamp_core_0.sliceA_1.bnb a_11950_14850# avss sg13_hv_nmos ad=1.125p pd=5u as=1.125p ps=5u w=4.5u l=0.5u
X1747 a_27150_14850# lpopamp_core_0.sliceA_1.zn_m zn_p avss sg13_hv_nmos ad=1.125p pd=5u as=1.125p ps=5u w=4.5u l=0.5u
X1748 avdd lpopamp_core_0.sliceB_1.zp_m lpopamp_core_0.sliceB_1.yp_p avdd sg13_hv_pmos ad=1.125p pd=5u as=1.125p ps=5u w=4.5u l=3.5u
X1749 lpopamp_core_0.sliceA_0.bna lpopamp_core_0.sliceA_0.bna a_2850_700# avss sg13_hv_nmos ad=1.125p pd=5u as=1.125p ps=5u w=4.5u l=3.5u
X1750 avdd zp_p out avdd sg13_hv_pmos ad=1.125p pd=5u as=1.125p ps=5u w=4.5u l=0.5u
X1751 lpopamp_core_0.sliceB_1.yn_m lpopamp_core_0.sliceB_1.zn_m a_16450_8400# avss sg13_hv_nmos ad=1.125p pd=5u as=1.125p ps=5u w=4.5u l=3.5u
X1752 a_10950_7150# lpopamp_core_0.sliceB_0.bnb lpopamp_core_0.sliceB_0.bna_ avss sg13_hv_nmos ad=1.125p pd=5u as=1.125p ps=5u w=4.5u l=0.5u
X1753 zp_p lpopamp_core_0.sliceA_0.zp_m lpopamp_core_0.sliceA_0.yp_m avdd sg13_hv_pmos ad=1.125p pd=5u as=1.125p ps=5u w=4.5u l=0.5u
X1754 lpopamp_core_0.sliceA_0.yp_p in_m a_14150_100# avss sg13_hv_nmos ad=1.125p pd=5u as=1.125p ps=5u w=4.5u l=0.5u
X1755 lpopamp_core_0.sliceA_0.bpa_r lpopamp_core_0.sliceA_0.bpb lpopamp_core_0.sliceA_0.bpb avdd sg13_hv_pmos ad=1.125p pd=5u as=1.125p ps=5u w=4.5u l=0.5u
X1756 a_9050_11850# lpopamp_core_0.sliceA_1.bpa_r a_8950_11850# avdd sg13_hv_pmos ad=1.125p pd=5u as=1.125p ps=5u w=4.5u l=0.5u
X1757 a_23350_700# lpopamp_core_0.sliceA_0.zn_m lpopamp_core_0.sliceA_0.yn_p avss sg13_hv_nmos ad=1.125p pd=5u as=1.125p ps=5u w=4.5u l=0.5u
X1758 a_6750_10800# lpopamp_core_0.sliceB_1.bpa_l a_6650_10800# avdd sg13_hv_pmos ad=1.125p pd=5u as=1.125p ps=5u w=4.5u l=0.5u
X1759 avdd lpopamp_core_0.sliceA_0.bpa lpopamp_core_0.sliceA_0.bpa avdd sg13_hv_pmos ad=1.125p pd=5u as=1.125p ps=5u w=4.5u l=3.5u
X1760 avdd zp_p out avdd sg13_hv_pmos ad=1.125p pd=5u as=1.125p ps=5u w=4.5u l=0.5u
X1761 a_15650_7150# lpopamp_core_0.sliceB_0.bna lpopamp_core_0.sliceB_0.xn avss sg13_hv_nmos ad=1.125p pd=5u as=1.125p ps=5u w=4.5u l=3.5u
X1762 a_20150_14250# lpopamp_core_0.sliceA_1.bnb a_20050_14250# avss sg13_hv_nmos ad=1.125p pd=5u as=1.125p ps=5u w=4.5u l=0.5u
X1763 a_26950_8400# lpopamp_core_0.sliceB_1.bnb zp_p avss sg13_hv_nmos ad=1.125p pd=5u as=1.125p ps=5u w=4.5u l=0.5u
X1764 lpopamp_core_0.sliceB_0.bna_ lpopamp_core_0.sliceB_0.bnb a_11950_7150# avss sg13_hv_nmos ad=1.125p pd=5u as=1.125p ps=5u w=4.5u l=0.5u
X1765 lpopamp_core_0.sliceA_1.yn_p lpopamp_core_0.sliceA_1.zn_m a_23950_14250# avss sg13_hv_nmos ad=1.125p pd=5u as=1.125p ps=5u w=4.5u l=0.5u
X1766 a_13950_14250# in_m lpopamp_core_0.sliceA_1.yp_p avss sg13_hv_nmos ad=1.125p pd=5u as=1.125p ps=5u w=4.5u l=0.5u
X1767 zp_p lpopamp_core_0.sliceB_1.bpb zn_p avdd sg13_hv_pmos ad=1.125p pd=5u as=1.125p ps=5u w=4.5u l=0.5u
X1768 lpopamp_core_0.sliceB_1.yn_p lpopamp_core_0.sliceB_1.zn_m a_23550_8400# avss sg13_hv_nmos ad=1.125p pd=5u as=1.125p ps=5u w=4.5u l=0.5u
X1769 lpopamp_core_0.sliceB_1.yn_m in_p lpopamp_core_0.sliceB_1.xp avdd sg13_hv_pmos ad=1.125p pd=5u as=1.125p ps=5u w=4.5u l=0.5u
X1770 a_20350_8400# lpopamp_core_0.sliceB_1.bnb lpopamp_core_0.sliceB_1.zp_m avss sg13_hv_nmos ad=1.125p pd=5u as=1.125p ps=5u w=4.5u l=0.5u
X1771 a_25750_7150# lpopamp_core_0.sliceB_0.zn_m lpopamp_core_0.sliceB_0.yn_m avss sg13_hv_nmos ad=1.125p pd=5u as=1.125p ps=5u w=4.5u l=0.5u
X1772 lpopamp_core_0.sliceA_1.yp_p lpopamp_core_0.sliceA_1.zp_m lpopamp_core_0.sliceA_1.zp_m avdd sg13_hv_pmos ad=1.125p pd=5u as=1.125p ps=5u w=4.5u l=0.5u
X1773 lpopamp_core_0.sliceB_0.bna_ lpopamp_core_0.sliceB_0.bnb a_9550_7150# avss sg13_hv_nmos ad=1.125p pd=5u as=1.125p ps=5u w=4.5u l=0.5u
X1774 lpopamp_core_0.sliceA_1.bpa_r lpopamp_core_0.sliceA_1.bpb lpopamp_core_0.sliceA_1.bpb avdd sg13_hv_pmos ad=1.125p pd=5u as=1.125p ps=5u w=4.5u l=0.5u
X1775 zp_p lpopamp_core_0.sliceA_1.zp_m lpopamp_core_0.sliceA_1.yp_m avdd sg13_hv_pmos ad=1.125p pd=5u as=1.125p ps=5u w=4.5u l=0.5u
X1776 a_14950_7800# in_m lpopamp_core_0.sliceB_1.xn avss sg13_hv_nmos ad=1.125p pd=5u as=1.125p ps=5u w=4.5u l=0.5u
X1777 avdd zp_p out avdd sg13_hv_pmos ad=1.125p pd=5u as=1.125p ps=5u w=4.5u l=0.5u
X1778 avss lpopamp_core_0.sliceA_0.zn_m a_24450_100# avss sg13_hv_nmos ad=1.125p pd=5u as=1.125p ps=5u w=4.5u l=3.5u
X1779 lpopamp_core_0.sliceA_0.yn_p in_m lpopamp_core_0.sliceA_0.xp avdd sg13_hv_pmos ad=1.125p pd=5u as=1.125p ps=5u w=4.5u l=0.5u
X1780 a_5250_14250# lpopamp_core_0.sliceA_1.bna avss avss sg13_hv_nmos ad=1.125p pd=5u as=1.125p ps=5u w=4.5u l=3.5u
X1781 lpopamp_core_0.sliceB_0.bpa_r lpopamp_core_0.sliceB_0.bpb lpopamp_core_0.sliceB_0.bpb avdd sg13_hv_pmos ad=1.125p pd=5u as=1.125p ps=5u w=4.5u l=0.5u
X1782 lpopamp_core_0.sliceA_1.xp in_p lpopamp_core_0.sliceA_1.yn_m avdd sg13_hv_pmos ad=1.125p pd=5u as=1.125p ps=5u w=4.5u l=0.5u
X1783 lpopamp_core_0.sliceB_1.bna_ lpopamp_core_0.sliceB_1.bnb a_11550_7800# avss sg13_hv_nmos ad=1.125p pd=5u as=1.125p ps=5u w=4.5u l=0.5u
X1784 lpopamp_core_0.sliceB_1.bpb lpopamp_core_0.sliceB_1.bpb lpopamp_core_0.sliceB_1.bpa_l avdd sg13_hv_pmos ad=1.125p pd=5u as=1.125p ps=5u w=4.5u l=0.5u
X1785 lpopamp_core_0.sliceA_1.bna_ lpopamp_core_0.sliceA_1.bna_ a_8750_14250# avss sg13_hv_nmos ad=1.125p pd=5u as=1.125p ps=5u w=4.5u l=0.5u
X1786 lpopamp_core_0.sliceB_0.yn_p in_m lpopamp_core_0.sliceB_0.xp avdd sg13_hv_pmos ad=1.125p pd=5u as=1.125p ps=5u w=4.5u l=0.5u
X1787 a_19650_7800# lpopamp_core_0.sliceB_1.bna avss avss sg13_hv_nmos ad=1.125p pd=5u as=1.125p ps=5u w=4.5u l=3.5u
X1788 a_13750_6550# in_p lpopamp_core_0.sliceB_0.xn avss sg13_hv_nmos ad=1.125p pd=5u as=1.125p ps=5u w=4.5u l=0.5u
X1789 lpopamp_core_0.sliceA_1.zn_m lpopamp_core_0.sliceA_1.bpb a_23850_11850# avdd sg13_hv_pmos ad=1.125p pd=5u as=1.125p ps=5u w=4.5u l=0.5u
X1790 lpopamp_core_0.sliceB_0.bna_ lpopamp_core_0.sliceB_0.bnb a_10350_6550# avss sg13_hv_nmos ad=1.125p pd=5u as=1.125p ps=5u w=4.5u l=0.5u
X1791 avdd lpopamp_core_0.sliceA_1.bpa lpopamp_core_0.sliceA_1.bpa avdd sg13_hv_pmos ad=1.125p pd=5u as=1.125p ps=5u w=4.5u l=3.5u
X1792 lpopamp_core_0.sliceB_1.bpa_r lpopamp_core_0.sliceB_1.bpb lpopamp_core_0.sliceB_1.bpb avdd sg13_hv_pmos ad=1.125p pd=5u as=1.125p ps=5u w=4.5u l=0.5u
X1793 zp_p lpopamp_core_0.sliceA_0.bpb zn_p avdd sg13_hv_pmos ad=1.125p pd=5u as=1.125p ps=5u w=4.5u l=0.5u
X1794 zp_p lpopamp_core_0.sliceB_1.bpb zn_p avdd sg13_hv_pmos ad=1.125p pd=5u as=1.125p ps=5u w=4.5u l=0.5u
X1795 lpopamp_core_0.sliceB_0.bpa lpopamp_core_0.sliceB_0.bpa avdd avdd sg13_hv_pmos ad=1.125p pd=5u as=1.125p ps=5u w=4.5u l=3.5u
X1796 lpopamp_core_0.sliceB_0.yn_p lpopamp_core_0.sliceB_0.zn_m a_18050_6550# avss sg13_hv_nmos ad=1.125p pd=5u as=1.125p ps=5u w=4.5u l=3.5u
X1797 lpopamp_core_0.sliceA_1.bnb lpopamp_core_0.sliceA_1.bnb a_10950_14850# avss sg13_hv_nmos ad=1.125p pd=5u as=1.125p ps=5u w=4.5u l=0.5u
X1798 lpopamp_core_0.sliceA_1.bpa_r lpopamp_core_0.sliceA_1.bpa_r a_9150_12450# avdd sg13_hv_pmos ad=1.125p pd=5u as=1.125p ps=5u w=4.5u l=0.5u
X1799 lpopamp_core_0.sliceA_1.xp in_m lpopamp_core_0.sliceA_1.yn_p avdd sg13_hv_pmos ad=1.125p pd=5u as=1.125p ps=5u w=4.5u l=0.5u
X1800 a_26150_14850# lpopamp_core_0.sliceA_1.zn_m lpopamp_core_0.sliceA_1.yn_m avss sg13_hv_nmos ad=1.125p pd=5u as=1.125p ps=5u w=4.5u l=0.5u
X1801 a_29850_10800# zp_p out avdd sg13_hv_pmos ad=1.125p pd=5u as=1.125p ps=5u w=4.5u l=0.5u
X1802 a_23850_2500# lpopamp_core_0.sliceA_0.bpb lpopamp_core_0.sliceA_0.zn_m avdd sg13_hv_pmos ad=1.125p pd=5u as=1.125p ps=5u w=4.5u l=0.5u
X1803 out zp_p avdd avdd sg13_hv_pmos ad=1.125p pd=5u as=1.125p ps=5u w=4.5u l=0.5u
X1804 lpopamp_core_0.sliceA_0.bpb lpopamp_core_0.sliceA_0.bpb lpopamp_core_0.sliceA_0.bpa_l avdd sg13_hv_pmos ad=1.125p pd=5u as=1.125p ps=5u w=4.5u l=0.5u
X1805 a_29750_7800# zn_p avss avss sg13_hv_nmos ad=1.125p pd=5u as=1.125p ps=5u w=4.5u l=0.5u
X1806 lpopamp_core_0.sliceB_1.xp in_m lpopamp_core_0.sliceB_1.yn_p avdd sg13_hv_pmos ad=1.125p pd=5u as=1.125p ps=5u w=4.5u l=0.5u
X1807 zn_p lpopamp_core_0.sliceA_0.zn_m a_25750_700# avss sg13_hv_nmos ad=1.125p pd=5u as=1.125p ps=5u w=4.5u l=0.5u
X1808 lpopamp_core_0.sliceA_0.xp in_p lpopamp_core_0.sliceA_0.yn_m avdd sg13_hv_pmos ad=1.125p pd=5u as=1.125p ps=5u w=4.5u l=0.5u
X1809 lpopamp_core_0.sliceB_0.yp_m lpopamp_core_0.sliceB_0.zp_m zp_p avdd sg13_hv_pmos ad=1.125p pd=5u as=1.125p ps=5u w=4.5u l=0.5u
X1810 lpopamp_core_0.sliceB_0.bpb lpopamp_core_0.sliceB_0.bpb lpopamp_core_0.sliceB_0.bpa_r avdd sg13_hv_pmos ad=1.125p pd=5u as=1.125p ps=5u w=4.5u l=0.5u
X1811 zp_p lpopamp_core_0.sliceB_1.bnb a_26350_7800# avss sg13_hv_nmos ad=1.125p pd=5u as=1.125p ps=5u w=4.5u l=0.5u
X1812 lpopamp_core_0.sliceA_0.yn_m lpopamp_core_0.sliceA_0.zn_m a_25950_100# avss sg13_hv_nmos ad=1.125p pd=5u as=1.125p ps=5u w=4.5u l=0.5u
X1813 a_20050_6550# lpopamp_core_0.sliceB_0.bnb a_20750_6550# avss sg13_hv_nmos ad=1.125p pd=5u as=1.125p ps=5u w=4.5u l=0.5u
X1814 avdd zp_p out avdd sg13_hv_pmos ad=1.125p pd=5u as=1.125p ps=5u w=4.5u l=0.5u
X1815 avss lpopamp_core_0.sliceB_0.enb lpopamp_core_0.sliceB_0.bna avss sg13_hv_nmos ad=1.125p pd=5u as=1.125p ps=5u w=4.5u l=1.5u
X1816 a_22450_4150# lpopamp_core_0.sliceB_0.bpa avdd avdd sg13_hv_pmos ad=1.125p pd=5u as=1.125p ps=5u w=4.5u l=3.5u
X1817 a_23150_7800# lpopamp_core_0.sliceB_1.zn_m lpopamp_core_0.sliceB_1.zn_m avss sg13_hv_nmos ad=1.125p pd=5u as=1.125p ps=5u w=4.5u l=0.5u
X1818 lpopamp_core_0.sliceB_0.tihi lpopamp_core_0.sliceB_0.tihi avdd avdd sg13_hv_pmos ad=1.125p pd=5u as=1.125p ps=5u w=4.5u l=9.5u
X1819 a_28550_6550# zn_p avss avss sg13_hv_nmos ad=1.125p pd=5u as=1.125p ps=5u w=4.5u l=0.5u
X1820 lpopamp_core_0.sliceA_1.bpa_l lpopamp_core_0.sliceA_1.bpb lpopamp_core_0.sliceA_1.bpb avdd sg13_hv_pmos ad=1.125p pd=5u as=1.125p ps=5u w=4.5u l=0.5u
X1821 avdd lpopamp_core_0.sliceB_0.zp_m lpopamp_core_0.sliceB_0.yp_m avdd sg13_hv_pmos ad=1.125p pd=5u as=1.125p ps=5u w=4.5u l=3.5u
X1822 lpopamp_core_0.sliceB_1.bpa lpopamp_core_0.sliceB_1.bpa avdd avdd sg13_hv_pmos ad=1.125p pd=5u as=1.125p ps=5u w=4.5u l=3.5u
X1823 a_9150_6550# lpopamp_core_0.sliceB_0.bnb lpopamp_core_0.sliceB_0.bnb avss sg13_hv_nmos ad=1.125p pd=5u as=1.125p ps=5u w=4.5u l=0.5u
X1824 lpopamp_core_0.sliceB_1.bpa_r lpopamp_core_0.sliceB_1.bpb lpopamp_core_0.sliceB_1.bpb avdd sg13_hv_pmos ad=1.125p pd=5u as=1.125p ps=5u w=4.5u l=0.5u
X1825 lpopamp_core_0.sliceA_0.bpb lpopamp_core_0.sliceA_0.bna a_6850_700# avss sg13_hv_nmos ad=1.125p pd=5u as=1.125p ps=5u w=4.5u l=3.5u
X1826 avss lpopamp_core_0.sliceA_1.enb zn_p avss sg13_hv_nmos ad=2.25p pd=10u as=1.125p ps=5u w=4.5u l=1.5u
X1827 a_22450_4150# lpopamp_core_0.sliceB_0.bpb lpopamp_core_0.sliceB_0.zn_m avdd sg13_hv_pmos ad=1.125p pd=5u as=1.125p ps=5u w=4.5u l=0.5u
X1828 a_10950_700# lpopamp_core_0.sliceA_0.bnb lpopamp_core_0.sliceA_0.bna_ avss sg13_hv_nmos ad=1.125p pd=5u as=1.125p ps=5u w=4.5u l=0.5u
X1829 a_22450_10200# lpopamp_core_0.sliceB_1.bpb lpopamp_core_0.sliceB_1.zn_m avdd sg13_hv_pmos ad=1.125p pd=5u as=1.125p ps=5u w=4.5u l=0.5u
X1830 a_17250_8400# lpopamp_core_0.sliceB_1.zn_m lpopamp_core_0.sliceB_1.yn_m avss sg13_hv_nmos ad=1.125p pd=5u as=1.125p ps=5u w=4.5u l=3.5u
X1831 lpopamp_core_0.sliceA_1.zn_m lpopamp_core_0.sliceA_1.zn_m a_22950_14250# avss sg13_hv_nmos ad=1.125p pd=5u as=1.125p ps=5u w=4.5u l=0.5u
X1832 a_13250_14250# lpopamp_core_0.sliceA_1.bna avss avss sg13_hv_nmos ad=1.125p pd=5u as=1.125p ps=5u w=4.5u l=3.5u
X1833 lpopamp_core_0.sliceB_1.yp_m lpopamp_core_0.sliceB_1.zp_m avdd avdd sg13_hv_pmos ad=1.125p pd=5u as=1.125p ps=5u w=4.5u l=3.5u
X1834 zp_p lpopamp_core_0.sliceA_0.bpb zn_p avdd sg13_hv_pmos ad=1.125p pd=5u as=1.125p ps=5u w=4.5u l=0.5u
X1835 a_11150_100# lpopamp_core_0.sliceA_0.bnb lpopamp_core_0.sliceA_0.bnb avss sg13_hv_nmos ad=1.125p pd=5u as=1.125p ps=5u w=4.5u l=0.5u
X1836 lpopamp_core_0.sliceA_0.bpa_r lpopamp_core_0.sliceA_0.bpb lpopamp_core_0.sliceA_0.bpb avdd sg13_hv_pmos ad=1.125p pd=5u as=1.125p ps=5u w=4.5u l=0.5u
X1837 a_27350_700# lpopamp_core_0.sliceA_0.zn_m lpopamp_core_0.sliceA_0.yn_m avss sg13_hv_nmos ad=1.125p pd=5u as=1.125p ps=5u w=4.5u l=0.5u
X1838 lpopamp_core_0.sliceA_0.zp_m lpopamp_core_0.sliceA_0.bnb a_20150_700# avss sg13_hv_nmos ad=1.125p pd=5u as=1.125p ps=5u w=4.5u l=0.5u
X1839 a_22450_2500# lpopamp_core_0.sliceA_0.bpb lpopamp_core_0.sliceA_0.zn_m avdd sg13_hv_pmos ad=1.125p pd=5u as=1.125p ps=5u w=4.5u l=0.5u
X1840 a_6550_2500# lpopamp_core_0.sliceA_0.bpa_l avdd avdd sg13_hv_pmos ad=1.125p pd=5u as=1.125p ps=5u w=4.5u l=0.5u
X1841 a_10350_8400# lpopamp_core_0.sliceB_1.bnb lpopamp_core_0.sliceB_1.bnb avss sg13_hv_nmos ad=1.125p pd=5u as=1.125p ps=5u w=4.5u l=0.5u
X1842 avss lpopamp_core_0.sliceB_0.bna a_15650_7150# avss sg13_hv_nmos ad=1.125p pd=5u as=1.125p ps=5u w=4.5u l=3.5u
X1843 avdd lpopamp_core_0.sliceA_1.bpa a_23850_11850# avdd sg13_hv_pmos ad=1.125p pd=5u as=1.125p ps=5u w=4.5u l=3.5u
X1844 a_12450_7150# lpopamp_core_0.sliceB_0.bna_ a_12350_7150# avss sg13_hv_nmos ad=1.125p pd=5u as=1.125p ps=5u w=4.5u l=0.5u
X1845 avdd lpopamp_core_0.sliceA_1.zp_m lpopamp_core_0.sliceA_1.yp_p avdd sg13_hv_pmos ad=1.125p pd=5u as=1.125p ps=5u w=4.5u l=3.5u
X1846 zp_p en avdd avdd sg13_hv_pmos ad=1.125p pd=5u as=1.125p ps=5u w=4.5u l=1.5u
X1847 lpopamp_core_0.sliceA_1.xp in_m lpopamp_core_0.sliceA_1.yn_p avdd sg13_hv_pmos ad=1.125p pd=5u as=1.125p ps=5u w=4.5u l=0.5u
X1848 a_6550_10200# lpopamp_core_0.sliceB_1.bpa_l avdd avdd sg13_hv_pmos ad=1.125p pd=5u as=1.125p ps=5u w=4.5u l=0.5u
X1849 a_8450_700# lpopamp_core_0.sliceA_0.bna_ a_8350_700# avss sg13_hv_nmos ad=1.125p pd=5u as=1.125p ps=5u w=4.5u l=0.5u
X1850 a_20750_8400# lpopamp_core_0.sliceB_1.bnb lpopamp_core_0.sliceB_1.zp_m avss sg13_hv_nmos ad=1.125p pd=5u as=1.125p ps=5u w=4.5u l=0.5u
X1851 a_12450_700# lpopamp_core_0.sliceA_0.bna_ a_12350_700# avss sg13_hv_nmos ad=1.125p pd=5u as=1.125p ps=5u w=4.5u l=0.5u
X1852 lpopamp_core_0.sliceA_1.bnb lpopamp_core_0.sliceA_1.bpa avdd avdd sg13_hv_pmos ad=1.125p pd=5u as=1.125p ps=5u w=4.5u l=3.5u
X1853 a_20050_14250# lpopamp_core_0.sliceA_1.bnb a_21150_14850# avss sg13_hv_nmos ad=1.125p pd=5u as=1.125p ps=5u w=4.5u l=0.5u
X1854 lpopamp_core_0.sliceA_1.yp_m lpopamp_core_0.sliceA_1.zp_m zp_p avdd sg13_hv_pmos ad=1.125p pd=5u as=1.125p ps=5u w=4.5u l=0.5u
X1855 lpopamp_core_0.sliceB_1.bnb lpopamp_core_0.sliceB_1.bnb a_8950_8400# avss sg13_hv_nmos ad=1.125p pd=5u as=1.125p ps=5u w=4.5u l=0.5u
X1856 a_28550_100# zn_p avss avss sg13_hv_nmos ad=1.125p pd=5u as=1.125p ps=5u w=4.5u l=0.5u
X1857 lpopamp_core_0.sliceB_1.yp_m lpopamp_core_0.sliceB_1.zp_m avdd avdd sg13_hv_pmos ad=1.125p pd=5u as=1.125p ps=5u w=4.5u l=3.5u
X1858 lpopamp_core_0.sliceA_1.bna_ lpopamp_core_0.sliceA_1.bnb a_9950_14850# avss sg13_hv_nmos ad=1.125p pd=5u as=1.125p ps=5u w=4.5u l=0.5u
X1859 lpopamp_core_0.sliceA_1.bpa_l lpopamp_core_0.sliceA_1.bpb lpopamp_core_0.sliceA_1.bpb avdd sg13_hv_pmos ad=1.125p pd=5u as=1.125p ps=5u w=4.5u l=0.5u
X1860 lpopamp_core_0.sliceB_1.yp_m lpopamp_core_0.sliceB_1.zp_m avdd avdd sg13_hv_pmos ad=1.125p pd=5u as=1.125p ps=5u w=4.5u l=3.5u
X1861 avdd zp_p out avdd sg13_hv_pmos ad=1.125p pd=5u as=1.125p ps=5u w=4.5u l=0.5u
X1862 lpopamp_core_0.sliceB_0.yn_p in_m lpopamp_core_0.sliceB_0.xp avdd sg13_hv_pmos ad=1.125p pd=5u as=1.125p ps=5u w=4.5u l=0.5u
X1863 lpopamp_core_0.sliceB_0.yn_m lpopamp_core_0.sliceB_0.zn_m a_27150_7150# avss sg13_hv_nmos ad=1.125p pd=5u as=1.125p ps=5u w=4.5u l=0.5u
X1864 a_20050_7800# lpopamp_core_0.sliceB_1.bna a_19650_7800# avss sg13_hv_nmos ad=1.125p pd=5u as=1.125p ps=5u w=4.5u l=3.5u
X1865 out zn_p a_28950_14850# avss sg13_hv_nmos ad=1.125p pd=5u as=1.125p ps=5u w=4.5u l=0.5u
X1866 avss lpopamp_core_0.sliceA_1.zn_m a_18850_14850# avss sg13_hv_nmos ad=1.125p pd=5u as=1.125p ps=5u w=4.5u l=3.5u
X1867 lpopamp_core_0.sliceB_0.bna_ lpopamp_core_0.sliceB_0.bnb a_10750_6550# avss sg13_hv_nmos ad=1.125p pd=5u as=1.125p ps=5u w=4.5u l=0.5u
X1868 zp_p lpopamp_core_0.sliceA_0.zp_m lpopamp_core_0.sliceA_0.yp_m avdd sg13_hv_pmos ad=1.125p pd=5u as=1.125p ps=5u w=4.5u l=0.5u
X1869 lpopamp_core_0.sliceB_0.bnb lpopamp_core_0.sliceB_0.bpa avdd avdd sg13_hv_pmos ad=1.125p pd=5u as=1.125p ps=5u w=4.5u l=3.5u
X1870 a_2850_100# lpopamp_core_0.sliceA_0.bna avss avss sg13_hv_nmos ad=1.125p pd=5u as=1.125p ps=5u w=4.5u l=3.5u
X1871 lpopamp_core_0.sliceA_0.bna_ lpopamp_core_0.sliceA_0.bnb a_9550_100# avss sg13_hv_nmos ad=1.125p pd=5u as=1.125p ps=5u w=4.5u l=0.5u
X1872 a_18850_6550# lpopamp_core_0.sliceB_0.zn_m lpopamp_core_0.sliceB_0.yn_p avss sg13_hv_nmos ad=1.125p pd=5u as=1.125p ps=5u w=4.5u l=3.5u
X1873 lpopamp_core_0.sliceA_1.bpa_l lpopamp_core_0.sliceA_1.bpb lpopamp_core_0.sliceA_1.bpb avdd sg13_hv_pmos ad=1.125p pd=5u as=1.125p ps=5u w=4.5u l=0.5u
X1874 avdd en lpopamp_core_0.sliceB_1.bpa avdd sg13_hv_pmos ad=1.125p pd=5u as=1.125p ps=5u w=4.5u l=1.5u
X1875 a_8550_3100# lpopamp_core_0.sliceA_0.bpa_l lpopamp_core_0.sliceA_0.bpa_l avdd sg13_hv_pmos ad=1.125p pd=5u as=1.125p ps=5u w=4.5u l=0.5u
X1876 out zn_p a_29750_700# avss sg13_hv_nmos ad=1.125p pd=5u as=1.125p ps=5u w=4.5u l=0.5u
X1877 lpopamp_core_0.sliceB_0.xn in_m a_15150_6550# avss sg13_hv_nmos ad=1.125p pd=5u as=1.125p ps=5u w=4.5u l=0.5u
X1878 a_8650_10800# lpopamp_core_0.sliceB_1.bpa_l a_8550_10800# avdd sg13_hv_pmos ad=1.125p pd=5u as=1.125p ps=5u w=4.5u l=0.5u
X1879 a_9950_14850# lpopamp_core_0.sliceA_1.bnb lpopamp_core_0.sliceA_1.bnb avss sg13_hv_nmos ad=1.125p pd=5u as=1.125p ps=5u w=4.5u l=0.5u
X1880 lpopamp_core_0.sliceA_0.zp_m lpopamp_core_0.sliceA_0.zp_m lpopamp_core_0.sliceA_0.yp_p avdd sg13_hv_pmos ad=1.125p pd=5u as=1.125p ps=5u w=4.5u l=0.5u
X1881 zn_p lpopamp_core_0.sliceB_0.bpb zp_p avdd sg13_hv_pmos ad=1.125p pd=5u as=1.125p ps=5u w=4.5u l=0.5u
X1882 lpopamp_core_0.sliceB_0.bpb lpopamp_core_0.sliceB_0.bpb lpopamp_core_0.sliceB_0.bpa_r avdd sg13_hv_pmos ad=1.125p pd=5u as=1.125p ps=5u w=4.5u l=0.5u
X1883 zp_p lpopamp_core_0.sliceB_1.bnb a_26750_7800# avss sg13_hv_nmos ad=1.125p pd=5u as=1.125p ps=5u w=4.5u l=0.5u
X1884 a_29050_3100# zp_p out avdd sg13_hv_pmos ad=1.125p pd=5u as=1.125p ps=5u w=4.5u l=0.5u
X1885 lpopamp_core_0.sliceB_1.bpa_r lpopamp_core_0.sliceB_1.bpb lpopamp_core_0.sliceB_1.bpb avdd sg13_hv_pmos ad=1.125p pd=5u as=1.125p ps=5u w=4.5u l=0.5u
X1886 lpopamp_core_0.sliceB_0.zn_m lpopamp_core_0.sliceB_0.bpb a_22450_4150# avdd sg13_hv_pmos ad=1.125p pd=5u as=1.125p ps=5u w=4.5u l=0.5u
X1887 a_11950_14250# lpopamp_core_0.sliceA_1.bnb lpopamp_core_0.sliceA_1.bnb avss sg13_hv_nmos ad=1.125p pd=5u as=1.125p ps=5u w=4.5u l=0.5u
X1888 zp_p lpopamp_core_0.sliceB_1.bpb zn_p avdd sg13_hv_pmos ad=1.125p pd=5u as=1.125p ps=5u w=4.5u l=0.5u
X1889 a_28950_6550# zn_p avss avss sg13_hv_nmos ad=1.125p pd=5u as=1.125p ps=5u w=4.5u l=0.5u
X1890 a_23550_7800# lpopamp_core_0.sliceB_1.zn_m lpopamp_core_0.sliceB_1.zn_m avss sg13_hv_nmos ad=1.125p pd=5u as=1.125p ps=5u w=4.5u l=0.5u
X1891 lpopamp_core_0.sliceB_1.yp_p lpopamp_core_0.sliceB_1.zp_m avdd avdd sg13_hv_pmos ad=1.125p pd=5u as=1.125p ps=5u w=4.5u l=3.5u
X1892 avdd zp_p out avdd sg13_hv_pmos ad=1.125p pd=5u as=1.125p ps=5u w=4.5u l=0.5u
X1893 lpopamp_core_0.sliceB_0.yp_m lpopamp_core_0.sliceB_0.zp_m avdd avdd sg13_hv_pmos ad=1.125p pd=5u as=1.125p ps=5u w=4.5u l=3.5u
X1894 lpopamp_core_0.sliceB_1.xp in_m lpopamp_core_0.sliceB_1.yn_p avdd sg13_hv_pmos ad=1.125p pd=5u as=1.125p ps=5u w=4.5u l=0.5u
X1895 lpopamp_core_0.sliceB_1.zp_m lpopamp_core_0.sliceB_1.bnb a_20150_7800# avss sg13_hv_nmos ad=1.125p pd=5u as=1.125p ps=5u w=4.5u l=0.5u
X1896 avss lpopamp_core_0.sliceB_1.bna a_4050_7800# avss sg13_hv_nmos ad=1.125p pd=5u as=1.125p ps=5u w=4.5u l=3.5u
X1897 a_20050_14250# lpopamp_core_0.sliceA_1.bna a_19650_14250# avss sg13_hv_nmos ad=1.125p pd=5u as=1.125p ps=5u w=4.5u l=3.5u
X1898 a_9550_6550# lpopamp_core_0.sliceB_0.bnb lpopamp_core_0.sliceB_0.bnb avss sg13_hv_nmos ad=1.125p pd=5u as=1.125p ps=5u w=4.5u l=0.5u
X1899 a_14950_700# in_p lpopamp_core_0.sliceA_0.xn avss sg13_hv_nmos ad=1.125p pd=5u as=1.125p ps=5u w=4.5u l=0.5u
X1900 lpopamp_core_0.sliceB_0.bpb lpopamp_core_0.sliceB_0.bpb lpopamp_core_0.sliceB_0.bpa_l avdd sg13_hv_pmos ad=1.125p pd=5u as=1.125p ps=5u w=4.5u l=0.5u
X1901 a_23850_11850# lpopamp_core_0.sliceA_1.bpa avdd avdd sg13_hv_pmos ad=1.125p pd=5u as=1.125p ps=5u w=4.5u l=3.5u
X1902 lpopamp_core_0.sliceA_0.xp in_m lpopamp_core_0.sliceA_0.yn_p avdd sg13_hv_pmos ad=1.125p pd=5u as=1.125p ps=5u w=4.5u l=0.5u
X1903 lpopamp_core_0.sliceB_0.zp_m lpopamp_core_0.sliceB_0.zp_m lpopamp_core_0.sliceB_0.yp_p avdd sg13_hv_pmos ad=1.125p pd=5u as=1.125p ps=5u w=4.5u l=0.5u
X1904 zn_p lpopamp_core_0.sliceA_1.bpb zp_p avdd sg13_hv_pmos ad=1.125p pd=5u as=1.125p ps=5u w=4.5u l=0.5u
X1905 a_15150_100# in_p lpopamp_core_0.sliceA_0.yp_m avss sg13_hv_nmos ad=1.125p pd=5u as=1.125p ps=5u w=4.5u l=0.5u
X1906 lpopamp_core_0.sliceA_1.bna lpopamp_core_0.sliceA_1.bna a_2850_14250# avss sg13_hv_nmos ad=1.125p pd=5u as=1.125p ps=5u w=4.5u l=3.5u
X1907 a_23950_100# lpopamp_core_0.sliceA_0.zn_m lpopamp_core_0.sliceA_0.zn_m avss sg13_hv_nmos ad=1.125p pd=5u as=1.125p ps=5u w=4.5u l=0.5u
X1908 lpopamp_core_0.sliceA_0.bpb lpopamp_core_0.sliceA_0.bpb lpopamp_core_0.sliceA_0.bpa_l avdd sg13_hv_pmos ad=1.125p pd=5u as=1.125p ps=5u w=4.5u l=0.5u
X1909 lpopamp_core_0.sliceB_1.bpa_r lpopamp_core_0.sliceB_1.bpb lpopamp_core_0.sliceB_1.bpb avdd sg13_hv_pmos ad=1.125p pd=5u as=1.125p ps=5u w=4.5u l=0.5u
X1910 a_10750_8400# lpopamp_core_0.sliceB_1.bnb lpopamp_core_0.sliceB_1.bnb avss sg13_hv_nmos ad=1.125p pd=5u as=1.125p ps=5u w=4.5u l=0.5u
X1911 zp_p en avdd avdd sg13_hv_pmos ad=1.125p pd=5u as=1.125p ps=5u w=4.5u l=1.5u
X1912 zn_p lpopamp_core_0.sliceA_0.bpb zp_p avdd sg13_hv_pmos ad=1.125p pd=5u as=1.125p ps=5u w=4.5u l=0.5u
X1913 avss lpopamp_core_0.sliceB_0.bna_ a_12750_7150# avss sg13_hv_nmos ad=1.125p pd=5u as=1.125p ps=5u w=4.5u l=0.5u
X1914 a_11150_11850# lpopamp_core_0.sliceA_1.bpa_r a_11050_11850# avdd sg13_hv_pmos ad=1.125p pd=5u as=1.125p ps=5u w=4.5u l=0.5u
X1915 lpopamp_core_0.sliceA_1.zp_m lpopamp_core_0.sliceA_1.bnb a_20150_14850# avss sg13_hv_nmos ad=1.125p pd=5u as=1.125p ps=5u w=4.5u l=0.5u
X1916 lpopamp_core_0.sliceA_1.yp_m lpopamp_core_0.sliceA_1.zp_m zp_p avdd sg13_hv_pmos ad=1.125p pd=5u as=1.125p ps=5u w=4.5u l=0.5u
X1917 a_15150_8400# in_m lpopamp_core_0.sliceB_1.yp_p avss sg13_hv_nmos ad=1.125p pd=5u as=1.125p ps=5u w=4.5u l=0.5u
X1918 lpopamp_core_0.sliceB_1.zn_m lpopamp_core_0.sliceB_1.bpb a_23850_10200# avdd sg13_hv_pmos ad=1.125p pd=5u as=1.125p ps=5u w=4.5u l=0.5u
X1919 lpopamp_core_0.sliceA_1.bpa_l lpopamp_core_0.sliceA_1.bpb lpopamp_core_0.sliceA_1.bpb avdd sg13_hv_pmos ad=1.125p pd=5u as=1.125p ps=5u w=4.5u l=0.5u
X1920 lpopamp_core_0.sliceA_0.zn_m lpopamp_core_0.sliceA_0.bpb a_23850_2500# avdd sg13_hv_pmos ad=1.125p pd=5u as=1.125p ps=5u w=4.5u l=0.5u
X1921 a_24450_14850# lpopamp_core_0.sliceA_1.zn_m lpopamp_core_0.sliceA_1.yn_p avss sg13_hv_nmos ad=1.125p pd=5u as=1.125p ps=5u w=4.5u l=3.5u
X1922 lpopamp_core_0.sliceB_1.yp_m lpopamp_core_0.sliceB_1.zp_m zp_p avdd sg13_hv_pmos ad=1.125p pd=5u as=1.125p ps=5u w=4.5u l=0.5u
X1923 lpopamp_core_0.sliceA_0.bpa lpopamp_core_0.sliceA_0.bna a_5250_700# avss sg13_hv_nmos ad=1.125p pd=5u as=1.125p ps=5u w=4.5u l=3.5u
X1924 lpopamp_core_0.sliceA_0.bpa_l lpopamp_core_0.sliceA_0.bpb lpopamp_core_0.sliceA_0.bpb avdd sg13_hv_pmos ad=1.125p pd=5u as=1.125p ps=5u w=4.5u l=0.5u
X1925 lpopamp_core_0.sliceB_1.xp in_p lpopamp_core_0.sliceB_1.yn_m avdd sg13_hv_pmos ad=1.125p pd=5u as=1.125p ps=5u w=4.5u l=0.5u
X1926 avss zn_p a_28750_8400# avss sg13_hv_nmos ad=1.125p pd=5u as=1.125p ps=5u w=4.5u l=0.5u
X1927 lpopamp_core_0.sliceA_1.enb en avdd avdd sg13_hv_pmos ad=1.125p pd=5u as=2.25p ps=10u w=4.5u l=1.5u
X1928 lpopamp_core_0.sliceB_1.bnb lpopamp_core_0.sliceB_1.bnb a_9350_8400# avss sg13_hv_nmos ad=1.125p pd=5u as=1.125p ps=5u w=4.5u l=0.5u
X1929 avss lpopamp_core_0.sliceB_1.bna a_6050_8400# avss sg13_hv_nmos ad=1.125p pd=5u as=1.125p ps=5u w=4.5u l=3.5u
X1930 lpopamp_core_0.sliceB_0.yn_m lpopamp_core_0.sliceB_0.zn_m a_27550_7150# avss sg13_hv_nmos ad=1.125p pd=5u as=1.125p ps=5u w=4.5u l=0.5u
X1931 lpopamp_core_0.sliceB_1.bpa_l lpopamp_core_0.sliceB_1.bpb lpopamp_core_0.sliceB_1.bpb avdd sg13_hv_pmos ad=1.125p pd=5u as=1.125p ps=5u w=4.5u l=0.5u
X1932 a_8950_14850# lpopamp_core_0.sliceA_1.bnb lpopamp_core_0.sliceA_1.bna_ avss sg13_hv_nmos ad=1.125p pd=5u as=1.125p ps=5u w=4.5u l=0.5u
X1933 lpopamp_core_0.sliceA_0.bnb lpopamp_core_0.sliceA_0.bpa avdd avdd sg13_hv_pmos ad=1.125p pd=5u as=1.125p ps=5u w=4.5u l=3.5u
X1934 a_8250_7150# lpopamp_core_0.sliceB_0.bna_ a_8150_7150# avss sg13_hv_nmos ad=1.125p pd=5u as=1.125p ps=5u w=4.5u l=0.5u
X1935 lpopamp_core_0.sliceA_1.zp_m lpopamp_core_0.sliceA_1.bnb a_20950_14250# avss sg13_hv_nmos ad=1.125p pd=5u as=1.125p ps=5u w=4.5u l=0.5u
X1936 avdd lpopamp_core_0.sliceB_0.bpa lpopamp_core_0.sliceB_0.bnb avdd sg13_hv_pmos ad=1.125p pd=5u as=1.125p ps=5u w=4.5u l=3.5u
X1937 a_10950_14250# lpopamp_core_0.sliceA_1.bnb lpopamp_core_0.sliceA_1.bna_ avss sg13_hv_nmos ad=1.125p pd=5u as=1.125p ps=5u w=4.5u l=0.5u
X1938 avss lpopamp_core_0.sliceB_0.zn_m a_18850_6550# avss sg13_hv_nmos ad=1.125p pd=5u as=1.125p ps=5u w=4.5u l=3.5u
X1939 lpopamp_core_0.sliceB_0.zp_m lpopamp_core_0.sliceB_0.bnb a_20950_7150# avss sg13_hv_nmos ad=1.125p pd=5u as=1.125p ps=5u w=4.5u l=0.5u
X1940 a_6850_100# lpopamp_core_0.sliceA_0.bna avss avss sg13_hv_nmos ad=1.125p pd=5u as=1.125p ps=5u w=4.5u l=3.5u
X1941 lpopamp_core_0.sliceA_1.xn in_p a_14750_14250# avss sg13_hv_nmos ad=1.125p pd=5u as=1.125p ps=5u w=4.5u l=0.5u
X1942 avdd zp_p out avdd sg13_hv_pmos ad=1.125p pd=5u as=1.125p ps=5u w=4.5u l=0.5u
X1943 a_10550_100# lpopamp_core_0.sliceA_0.bnb lpopamp_core_0.sliceA_0.bna_ avss sg13_hv_nmos ad=1.125p pd=5u as=1.125p ps=5u w=4.5u l=0.5u
X1944 lpopamp_core_0.sliceB_0.yn_m in_p lpopamp_core_0.sliceB_0.xp avdd sg13_hv_pmos ad=1.125p pd=5u as=1.125p ps=5u w=4.5u l=0.5u
X1945 a_29950_14250# zn_p out avss sg13_hv_nmos ad=1.125p pd=5u as=1.125p ps=5u w=4.5u l=0.5u
X1946 a_8950_3100# lpopamp_core_0.sliceA_0.bpa_r avdd avdd sg13_hv_pmos ad=1.125p pd=5u as=1.125p ps=5u w=4.5u l=0.5u
X1947 lpopamp_core_0.sliceB_1.bnb lpopamp_core_0.sliceB_1.bnb a_10150_7800# avss sg13_hv_nmos ad=1.125p pd=5u as=1.125p ps=5u w=4.5u l=0.5u
X1948 a_26750_700# lpopamp_core_0.sliceA_0.bnb zn_p avss sg13_hv_nmos ad=1.125p pd=5u as=1.125p ps=5u w=4.5u l=0.5u
X1949 avdd lpopamp_core_0.sliceA_0.zp_m lpopamp_core_0.sliceA_0.yp_p avdd sg13_hv_pmos ad=1.125p pd=5u as=1.125p ps=5u w=4.5u l=3.5u
X1950 a_12350_6550# lpopamp_core_0.sliceB_0.bna_ a_12250_6550# avss sg13_hv_nmos ad=1.125p pd=5u as=1.125p ps=5u w=4.5u l=0.5u
X1951 lpopamp_core_0.sliceA_1.zn_m lpopamp_core_0.sliceA_1.bpb a_22450_11850# avdd sg13_hv_pmos ad=1.125p pd=5u as=1.125p ps=5u w=4.5u l=0.5u
X1952 lpopamp_core_0.sliceA_1.bnb lpopamp_core_0.sliceA_1.bpa avdd avdd sg13_hv_pmos ad=1.125p pd=5u as=1.125p ps=5u w=4.5u l=3.5u
X1953 a_29450_3100# zp_p out avdd sg13_hv_pmos ad=1.125p pd=5u as=1.125p ps=5u w=4.5u l=0.5u
X1954 lpopamp_core_0.sliceB_0.bpb lpopamp_core_0.sliceB_0.bpb lpopamp_core_0.sliceB_0.bpa_r avdd sg13_hv_pmos ad=1.125p pd=5u as=1.125p ps=5u w=4.5u l=0.5u
X1955 avdd en lpopamp_core_0.sliceA_0.enb avdd sg13_hv_pmos ad=1.125p pd=5u as=1.125p ps=5u w=4.5u l=1.5u
X1956 lpopamp_core_0.sliceB_0.zn_m lpopamp_core_0.sliceB_0.bpb a_22450_4150# avdd sg13_hv_pmos ad=1.125p pd=5u as=1.125p ps=5u w=4.5u l=0.5u
X1957 lpopamp_core_0.sliceB_0.bpa_l lpopamp_core_0.sliceB_0.bpa_l a_6750_4750# avdd sg13_hv_pmos ad=1.125p pd=5u as=1.125p ps=5u w=4.5u l=0.5u
X1958 a_23950_7800# lpopamp_core_0.sliceB_1.zn_m lpopamp_core_0.sliceB_1.zn_m avss sg13_hv_nmos ad=1.125p pd=5u as=1.125p ps=5u w=4.5u l=0.5u
X1959 zp_p lpopamp_core_0.sliceA_0.zp_m lpopamp_core_0.sliceA_0.yp_m avdd sg13_hv_pmos ad=1.125p pd=5u as=1.125p ps=5u w=4.5u l=0.5u
X1960 lpopamp_core_0.sliceB_1.bpa en avdd avdd sg13_hv_pmos ad=1.125p pd=5u as=1.125p ps=5u w=4.5u l=1.5u
X1961 avdd lpopamp_core_0.sliceB_0.tihi lpopamp_core_0.sliceB_0.tihi avdd sg13_hv_pmos ad=1.125p pd=5u as=1.125p ps=5u w=4.5u l=9.5u
X1962 lpopamp_core_0.sliceB_1.zp_m lpopamp_core_0.sliceB_1.bnb a_20550_7800# avss sg13_hv_nmos ad=1.125p pd=5u as=1.125p ps=5u w=4.5u l=0.5u
X1963 lpopamp_core_0.sliceB_1.bna lpopamp_core_0.sliceB_1.enb avss avss sg13_hv_nmos ad=1.125p pd=5u as=1.125p ps=5u w=4.5u l=1.5u
X1964 lpopamp_core_0.sliceB_1.bpa_l lpopamp_core_0.sliceB_1.bpb lpopamp_core_0.sliceB_1.bpb avdd sg13_hv_pmos ad=1.125p pd=5u as=1.125p ps=5u w=4.5u l=0.5u
X1965 a_9950_6550# lpopamp_core_0.sliceB_0.bnb lpopamp_core_0.sliceB_0.bnb avss sg13_hv_nmos ad=1.125p pd=5u as=1.125p ps=5u w=4.5u l=0.5u
X1966 a_9750_14250# lpopamp_core_0.sliceA_1.bnb lpopamp_core_0.sliceA_1.bna_ avss sg13_hv_nmos ad=1.125p pd=5u as=1.125p ps=5u w=4.5u l=0.5u
X1967 zp_p lpopamp_core_0.sliceB_0.zp_m lpopamp_core_0.sliceB_0.yp_m avdd sg13_hv_pmos ad=1.125p pd=5u as=1.125p ps=5u w=4.5u l=0.5u
X1968 lpopamp_core_0.sliceB_0.bpb lpopamp_core_0.sliceB_0.bpb lpopamp_core_0.sliceB_0.bpa_l avdd sg13_hv_pmos ad=1.125p pd=5u as=1.125p ps=5u w=4.5u l=0.5u
X1969 lpopamp_core_0.sliceA_0.bnb lpopamp_core_0.sliceA_0.bnb a_11750_700# avss sg13_hv_nmos ad=1.125p pd=5u as=1.125p ps=5u w=4.5u l=0.5u
X1970 avss lpopamp_core_0.sliceA_0.zn_m a_18850_700# avss sg13_hv_nmos ad=1.125p pd=5u as=1.125p ps=5u w=4.5u l=3.5u
X1971 lpopamp_core_0.sliceA_1.zp_m lpopamp_core_0.sliceA_1.zp_m lpopamp_core_0.sliceA_1.yp_p avdd sg13_hv_pmos ad=1.125p pd=5u as=1.125p ps=5u w=4.5u l=0.5u
X1972 a_23850_4150# lpopamp_core_0.sliceB_0.bpb lpopamp_core_0.sliceB_0.zn_m avdd sg13_hv_pmos ad=1.125p pd=5u as=1.125p ps=5u w=4.5u l=0.5u
X1973 avdd en lpopamp_core_0.sliceA_1.enb avdd sg13_hv_pmos ad=1.125p pd=5u as=1.125p ps=5u w=4.5u l=1.5u
X1974 lpopamp_core_0.sliceA_1.bpb lpopamp_core_0.sliceA_1.bpb lpopamp_core_0.sliceA_1.bpa_r avdd sg13_hv_pmos ad=1.125p pd=5u as=1.125p ps=5u w=4.5u l=0.5u
X1975 lpopamp_core_0.sliceB_1.zn_m lpopamp_core_0.sliceB_1.bpb a_22450_10200# avdd sg13_hv_pmos ad=1.125p pd=5u as=1.125p ps=5u w=4.5u l=0.5u
X1976 lpopamp_core_0.sliceA_0.bna_ lpopamp_core_0.sliceA_0.bnb a_11950_100# avss sg13_hv_nmos ad=1.125p pd=5u as=1.125p ps=5u w=4.5u l=0.5u
X1977 ib en lpopamp_core_0.sliceB_0.bna avss sg13_hv_nmos ad=1.125p pd=5u as=1.125p ps=5u w=4.5u l=1.5u
X1978 a_23150_14850# lpopamp_core_0.sliceA_1.zn_m lpopamp_core_0.sliceA_1.zn_m avss sg13_hv_nmos ad=1.125p pd=5u as=1.125p ps=5u w=4.5u l=0.5u
X1979 out zp_p a_29050_11850# avdd sg13_hv_pmos ad=1.125p pd=5u as=1.125p ps=5u w=4.5u l=0.5u
X1980 avdd lpopamp_core_0.sliceB_1.bpa lpopamp_core_0.sliceB_1.bnb avdd sg13_hv_pmos ad=1.125p pd=5u as=1.125p ps=5u w=4.5u l=3.5u
X1981 avdd lpopamp_core_0.sliceA_0.zp_m lpopamp_core_0.sliceA_0.yp_p avdd sg13_hv_pmos ad=1.125p pd=5u as=1.125p ps=5u w=4.5u l=3.5u
X1982 a_21150_700# lpopamp_core_0.sliceA_0.bnb lpopamp_core_0.sliceA_0.zp_m avss sg13_hv_nmos ad=1.125p pd=5u as=1.125p ps=5u w=4.5u l=0.5u
X1983 a_20050_100# lpopamp_core_0.sliceA_0.bnb a_20750_100# avss sg13_hv_nmos ad=1.125p pd=5u as=1.125p ps=5u w=4.5u l=0.5u
X1984 a_27150_6550# lpopamp_core_0.sliceB_0.zn_m zn_p avss sg13_hv_nmos ad=1.125p pd=5u as=1.125p ps=5u w=4.5u l=0.5u
X1985 zn_p lpopamp_core_0.sliceA_1.bnb a_26950_14850# avss sg13_hv_nmos ad=1.125p pd=5u as=1.125p ps=5u w=4.5u l=0.5u
X1986 a_17250_14850# lpopamp_core_0.sliceA_1.zn_m lpopamp_core_0.sliceA_1.yn_p avss sg13_hv_nmos ad=1.125p pd=5u as=1.125p ps=5u w=4.5u l=3.5u
X1987 lpopamp_core_0.sliceA_0.yp_m lpopamp_core_0.sliceA_0.zp_m zp_p avdd sg13_hv_pmos ad=1.125p pd=5u as=1.125p ps=5u w=4.5u l=0.5u
X1988 zn_p lpopamp_core_0.sliceA_0.enb avss avss sg13_hv_nmos ad=1.125p pd=5u as=1.125p ps=5u w=4.5u l=1.5u
X1989 avdd lpopamp_core_0.sliceA_0.bpa a_23850_2500# avdd sg13_hv_pmos ad=1.125p pd=5u as=1.125p ps=5u w=4.5u l=3.5u
X1990 lpopamp_core_0.sliceA_0.bpa_l lpopamp_core_0.sliceA_0.bpb lpopamp_core_0.sliceA_0.bpb avdd sg13_hv_pmos ad=1.125p pd=5u as=1.125p ps=5u w=4.5u l=0.5u
X1991 a_12250_8400# lpopamp_core_0.sliceB_1.bna_ a_12150_8400# avss sg13_hv_nmos ad=1.125p pd=5u as=1.125p ps=5u w=4.5u l=0.5u
X1992 a_9350_700# lpopamp_core_0.sliceA_0.bnb lpopamp_core_0.sliceA_0.bna_ avss sg13_hv_nmos ad=1.125p pd=5u as=1.125p ps=5u w=4.5u l=0.5u
X1993 lpopamp_core_0.sliceA_0.xn lpopamp_core_0.sliceA_0.bna a_13250_700# avss sg13_hv_nmos ad=1.125p pd=5u as=1.125p ps=5u w=4.5u l=3.5u
X1994 a_6650_10800# lpopamp_core_0.sliceB_1.bpa_l a_6550_10800# avdd sg13_hv_pmos ad=1.125p pd=5u as=1.125p ps=5u w=4.5u l=0.5u
X1995 lpopamp_core_0.sliceA_0.yp_p lpopamp_core_0.sliceA_0.zp_m lpopamp_core_0.sliceA_0.zp_m avdd sg13_hv_pmos ad=1.125p pd=5u as=1.125p ps=5u w=4.5u l=0.5u
X1996 a_14350_7150# in_p lpopamp_core_0.sliceB_0.yp_m avss sg13_hv_nmos ad=1.125p pd=5u as=1.125p ps=5u w=4.5u l=0.5u
X1997 a_25950_8400# lpopamp_core_0.sliceB_1.zn_m zn_p avss sg13_hv_nmos ad=1.125p pd=5u as=1.125p ps=5u w=4.5u l=0.5u
X1998 lpopamp_core_0.sliceB_1.bnb lpopamp_core_0.sliceB_1.bnb a_9750_8400# avss sg13_hv_nmos ad=1.125p pd=5u as=1.125p ps=5u w=4.5u l=0.5u
X1999 out zn_p a_29350_100# avss sg13_hv_nmos ad=1.125p pd=5u as=1.125p ps=5u w=4.5u l=0.5u
X2000 lpopamp_core_0.sliceB_0.bnb lpopamp_core_0.sliceB_0.bnb a_10950_7150# avss sg13_hv_nmos ad=1.125p pd=5u as=1.125p ps=5u w=4.5u l=0.5u
X2001 avdd lpopamp_core_0.sliceB_1.bpa lpopamp_core_0.sliceB_1.bnb avdd sg13_hv_pmos ad=1.125p pd=5u as=1.125p ps=5u w=4.5u l=3.5u
X2002 lpopamp_core_0.sliceA_1.yp_p in_m a_13750_14250# avss sg13_hv_nmos ad=1.125p pd=5u as=1.125p ps=5u w=4.5u l=0.5u
X2003 zn_p lpopamp_core_0.sliceB_1.bpb zp_p avdd sg13_hv_pmos ad=1.125p pd=5u as=1.125p ps=5u w=4.5u l=0.5u
X2004 a_28950_14250# zn_p avss avss sg13_hv_nmos ad=1.125p pd=5u as=1.125p ps=5u w=4.5u l=0.5u
X2005 a_6850_8400# lpopamp_core_0.sliceB_1.bna avss avss sg13_hv_nmos ad=1.125p pd=5u as=1.125p ps=5u w=4.5u l=3.5u
X2006 a_18050_14250# lpopamp_core_0.sliceA_1.zn_m avss avss sg13_hv_nmos ad=1.125p pd=5u as=1.125p ps=5u w=4.5u l=3.5u
X2007 avdd lpopamp_core_0.sliceA_0.bpa lpopamp_core_0.sliceA_0.bnb avdd sg13_hv_pmos ad=1.125p pd=5u as=1.125p ps=5u w=4.5u l=3.5u
X2008 lpopamp_core_0.sliceA_1.zp_m lpopamp_core_0.sliceA_1.zp_m lpopamp_core_0.sliceA_1.yp_p avdd sg13_hv_pmos ad=1.125p pd=5u as=1.125p ps=5u w=4.5u l=0.5u
X2009 a_8650_7150# lpopamp_core_0.sliceB_0.bna_ a_8550_7150# avss sg13_hv_nmos ad=1.125p pd=5u as=1.125p ps=5u w=4.5u l=0.5u
X2010 lpopamp_core_0.sliceA_1.bpb lpopamp_core_0.sliceA_1.bpb lpopamp_core_0.sliceA_1.bpa_r avdd sg13_hv_pmos ad=1.125p pd=5u as=1.125p ps=5u w=4.5u l=0.5u
X2011 zn_p lpopamp_core_0.sliceB_1.bnb a_26950_8400# avss sg13_hv_nmos ad=1.125p pd=5u as=1.125p ps=5u w=4.5u l=0.5u
X2012 lpopamp_core_0.sliceA_1.yp_m lpopamp_core_0.sliceA_1.zp_m zp_p avdd sg13_hv_pmos ad=1.125p pd=5u as=1.125p ps=5u w=4.5u l=0.5u
X2013 lpopamp_core_0.sliceB_0.yp_m lpopamp_core_0.sliceB_0.bpa avdd avdd sg13_hv_pmos ad=1.125p pd=5u as=1.125p ps=5u w=4.5u l=3.5u
X2014 a_13950_7800# in_p lpopamp_core_0.sliceB_1.yp_m avss sg13_hv_nmos ad=1.125p pd=5u as=1.125p ps=5u w=4.5u l=0.5u
X2015 lpopamp_core_0.sliceB_0.bpa lpopamp_core_0.sliceB_0.bna a_5250_7150# avss sg13_hv_nmos ad=1.125p pd=5u as=1.125p ps=5u w=4.5u l=3.5u
X2016 avdd lpopamp_core_0.sliceB_1.tihi lpopamp_core_0.sliceB_1.tihi avdd sg13_hv_pmos ad=1.125p pd=5u as=1.125p ps=5u w=4.5u l=9.5u
X2017 lpopamp_core_0.sliceA_0.xp lpopamp_core_0.sliceA_0.bpa avdd avdd sg13_hv_pmos ad=1.125p pd=5u as=1.125p ps=5u w=4.5u l=3.5u
X2018 out zp_p avdd avdd sg13_hv_pmos ad=1.125p pd=5u as=1.125p ps=5u w=4.5u l=0.5u
X2019 a_14550_100# in_p lpopamp_core_0.sliceA_0.xn avss sg13_hv_nmos ad=1.125p pd=5u as=1.125p ps=5u w=4.5u l=0.5u
X2020 a_29150_7150# zn_p out avss sg13_hv_nmos ad=1.125p pd=5u as=1.125p ps=5u w=4.5u l=0.5u
X2021 lpopamp_core_0.sliceA_1.yn_m in_p lpopamp_core_0.sliceA_1.xp avdd sg13_hv_pmos ad=1.125p pd=5u as=1.125p ps=5u w=4.5u l=0.5u
X2022 lpopamp_core_0.sliceB_1.bnb lpopamp_core_0.sliceB_1.bnb a_10550_7800# avss sg13_hv_nmos ad=1.125p pd=5u as=1.125p ps=5u w=4.5u l=0.5u
X2023 lpopamp_core_0.sliceB_1.bpa_l lpopamp_core_0.sliceB_1.bpb lpopamp_core_0.sliceB_1.bpb avdd sg13_hv_pmos ad=1.125p pd=5u as=1.125p ps=5u w=4.5u l=0.5u
X2024 a_8750_14250# lpopamp_core_0.sliceA_1.bna_ a_8650_14250# avss sg13_hv_nmos ad=1.125p pd=5u as=1.125p ps=5u w=4.5u l=0.5u
X2025 lpopamp_core_0.sliceA_0.yn_p lpopamp_core_0.sliceA_0.zn_m a_23550_700# avss sg13_hv_nmos ad=1.125p pd=5u as=1.125p ps=5u w=4.5u l=0.5u
X2026 avdd lpopamp_core_0.sliceB_0.bpa lpopamp_core_0.sliceB_0.xp avdd sg13_hv_pmos ad=1.125p pd=5u as=1.125p ps=5u w=4.5u l=3.5u
X2027 a_12750_6550# lpopamp_core_0.sliceB_0.bna_ a_12650_6550# avss sg13_hv_nmos ad=1.125p pd=5u as=1.125p ps=5u w=4.5u l=0.5u
X2028 avdd lpopamp_core_0.sliceA_1.zp_m lpopamp_core_0.sliceA_1.yp_p avdd sg13_hv_pmos ad=1.125p pd=5u as=1.125p ps=5u w=4.5u l=3.5u
X2029 a_29850_3100# zp_p out avdd sg13_hv_pmos ad=1.125p pd=5u as=1.125p ps=5u w=4.5u l=0.5u
X2030 lpopamp_core_0.sliceB_1.yp_p in_m a_14950_7800# avss sg13_hv_nmos ad=1.125p pd=5u as=1.125p ps=5u w=4.5u l=0.5u
X2031 lpopamp_core_0.sliceB_0.bpb lpopamp_core_0.sliceB_0.bpb lpopamp_core_0.sliceB_0.bpa_r avdd sg13_hv_pmos ad=1.125p pd=5u as=1.125p ps=5u w=4.5u l=0.5u
X2032 a_23850_11850# lpopamp_core_0.sliceA_1.bpb lpopamp_core_0.sliceA_1.zn_m avdd sg13_hv_pmos ad=1.125p pd=5u as=1.125p ps=5u w=4.5u l=0.5u
X2033 lpopamp_core_0.sliceB_0.xp in_m lpopamp_core_0.sliceB_0.yn_p avdd sg13_hv_pmos ad=1.125p pd=5u as=1.125p ps=5u w=4.5u l=0.5u
X2034 a_22450_14850# lpopamp_core_0.sliceA_1.zn_m avss avss sg13_hv_nmos ad=1.125p pd=5u as=1.125p ps=5u w=4.5u l=3.5u
X2035 avdd lpopamp_core_0.sliceA_1.zp_m lpopamp_core_0.sliceA_1.yp_m avdd sg13_hv_pmos ad=1.125p pd=5u as=1.125p ps=5u w=4.5u l=3.5u
X2036 lpopamp_core_0.sliceB_1.bpb lpopamp_core_0.sliceB_1.bpb lpopamp_core_0.sliceB_1.bpa_r avdd sg13_hv_pmos ad=1.125p pd=5u as=1.125p ps=5u w=4.5u l=0.5u
X2037 zn_p lpopamp_core_0.sliceB_1.bpb zp_p avdd sg13_hv_pmos ad=1.125p pd=5u as=1.125p ps=5u w=4.5u l=0.5u
X2038 a_9150_12450# lpopamp_core_0.sliceA_1.bpa_r a_9050_12450# avdd sg13_hv_pmos ad=1.125p pd=5u as=1.125p ps=5u w=4.5u l=0.5u
X2039 a_5250_7800# lpopamp_core_0.sliceB_1.bna avss avss sg13_hv_nmos ad=1.125p pd=5u as=1.125p ps=5u w=4.5u l=3.5u
X2040 lpopamp_core_0.sliceA_1.yn_m lpopamp_core_0.sliceA_1.zn_m a_25950_14850# avss sg13_hv_nmos ad=1.125p pd=5u as=1.125p ps=5u w=4.5u l=0.5u
X2041 out zp_p avdd avdd sg13_hv_pmos ad=1.125p pd=5u as=1.125p ps=5u w=4.5u l=0.5u
X2042 avss lpopamp_core_0.sliceA_0.enb lpopamp_core_0.sliceA_0.bna avss sg13_hv_nmos ad=1.125p pd=5u as=1.125p ps=5u w=4.5u l=1.5u
X2043 lpopamp_core_0.sliceA_0.bpb lpopamp_core_0.sliceA_0.bpb lpopamp_core_0.sliceA_0.bpa_l avdd sg13_hv_pmos ad=1.125p pd=5u as=1.125p ps=5u w=4.5u l=0.5u
X2044 zp_p lpopamp_core_0.sliceB_0.bpb zn_p avdd sg13_hv_pmos ad=1.125p pd=5u as=1.125p ps=5u w=4.5u l=0.5u
X2045 a_28750_7800# zn_p out avss sg13_hv_nmos ad=1.125p pd=5u as=1.125p ps=5u w=4.5u l=0.5u
X2046 lpopamp_core_0.sliceB_1.yn_p in_m lpopamp_core_0.sliceB_1.xp avdd sg13_hv_pmos ad=1.125p pd=5u as=1.125p ps=5u w=4.5u l=0.5u
X2047 a_23850_4150# lpopamp_core_0.sliceB_0.bpb lpopamp_core_0.sliceB_0.zn_m avdd sg13_hv_pmos ad=1.125p pd=5u as=1.125p ps=5u w=4.5u l=0.5u
X2048 lpopamp_core_0.sliceB_0.bpb lpopamp_core_0.sliceB_0.bpb lpopamp_core_0.sliceB_0.bpa_l avdd sg13_hv_pmos ad=1.125p pd=5u as=1.125p ps=5u w=4.5u l=0.5u
X2049 a_9350_7800# lpopamp_core_0.sliceB_1.bnb lpopamp_core_0.sliceB_1.bna_ avss sg13_hv_nmos ad=1.125p pd=5u as=1.125p ps=5u w=4.5u l=0.5u
X2050 a_4050_6550# lpopamp_core_0.sliceB_0.bna lpopamp_core_0.sliceB_0.bna avss sg13_hv_nmos ad=1.125p pd=5u as=1.125p ps=5u w=4.5u l=3.5u
X2051 lpopamp_core_0.sliceA_0.yp_m lpopamp_core_0.sliceA_0.zp_m avdd avdd sg13_hv_pmos ad=1.125p pd=5u as=1.125p ps=5u w=4.5u l=3.5u
X2052 a_28650_4150# zp_p out avdd sg13_hv_pmos ad=1.125p pd=5u as=1.125p ps=5u w=4.5u l=0.5u
X2053 lpopamp_core_0.sliceB_0.zp_m lpopamp_core_0.sliceB_0.zp_m lpopamp_core_0.sliceB_0.yp_p avdd sg13_hv_pmos ad=1.125p pd=5u as=1.125p ps=5u w=4.5u l=0.5u
X2054 a_27550_6550# lpopamp_core_0.sliceB_0.zn_m zn_p avss sg13_hv_nmos ad=1.125p pd=5u as=1.125p ps=5u w=4.5u l=0.5u
X2055 a_22450_7800# lpopamp_core_0.sliceB_1.zn_m avss avss sg13_hv_nmos ad=1.125p pd=5u as=1.125p ps=5u w=4.5u l=3.5u
X2056 zp_p lpopamp_core_0.sliceB_0.zp_m lpopamp_core_0.sliceB_0.yp_m avdd sg13_hv_pmos ad=1.125p pd=5u as=1.125p ps=5u w=4.5u l=0.5u
X2057 avdd lpopamp_core_0.sliceA_0.bpa_r a_11150_2500# avdd sg13_hv_pmos ad=1.125p pd=5u as=1.125p ps=5u w=4.5u l=0.5u
X2058 lpopamp_core_0.sliceB_0.bpa_r lpopamp_core_0.sliceB_0.bpa_r a_9150_4150# avdd sg13_hv_pmos ad=1.125p pd=5u as=1.125p ps=5u w=4.5u l=0.5u
X2059 lpopamp_core_0.sliceA_1.bpb lpopamp_core_0.sliceA_1.bna a_6850_14850# avss sg13_hv_nmos ad=1.125p pd=5u as=1.125p ps=5u w=4.5u l=3.5u
X2060 lpopamp_core_0.sliceB_1.bpb lpopamp_core_0.sliceB_1.bpb lpopamp_core_0.sliceB_1.bpa_r avdd sg13_hv_pmos ad=1.125p pd=5u as=1.125p ps=5u w=4.5u l=0.5u
X2061 a_8150_6550# lpopamp_core_0.sliceB_0.bna_ avss avss sg13_hv_nmos ad=1.125p pd=5u as=1.125p ps=5u w=4.5u l=0.5u
X2062 avdd en zp_p avdd sg13_hv_pmos ad=2.25p pd=10u as=1.125p ps=5u w=4.5u l=1.5u
X2063 lpopamp_core_0.sliceB_1.zn_m lpopamp_core_0.sliceB_1.bpb a_22450_10200# avdd sg13_hv_pmos ad=1.125p pd=5u as=1.125p ps=5u w=4.5u l=0.5u
X2064 avss lpopamp_core_0.sliceA_1.bna_ a_12750_14250# avss sg13_hv_nmos ad=1.125p pd=5u as=1.125p ps=5u w=4.5u l=0.5u
X2065 lpopamp_core_0.sliceA_0.yp_m lpopamp_core_0.sliceA_0.zp_m avdd avdd sg13_hv_pmos ad=1.125p pd=5u as=1.125p ps=5u w=4.5u l=3.5u
X2066 avdd lpopamp_core_0.sliceA_0.bpa_l a_8750_2500# avdd sg13_hv_pmos ad=1.125p pd=5u as=1.125p ps=5u w=4.5u l=0.5u
X2067 a_12650_8400# lpopamp_core_0.sliceB_1.bna_ a_12550_8400# avss sg13_hv_nmos ad=1.125p pd=5u as=1.125p ps=5u w=4.5u l=0.5u
X2068 lpopamp_core_0.sliceA_0.bnb lpopamp_core_0.sliceA_0.bnb a_10150_700# avss sg13_hv_nmos ad=1.125p pd=5u as=1.125p ps=5u w=4.5u l=0.5u
X2069 avss lpopamp_core_0.sliceA_0.zn_m a_17250_700# avss sg13_hv_nmos ad=1.125p pd=5u as=1.125p ps=5u w=4.5u l=3.5u
X2070 lpopamp_core_0.sliceA_0.yp_p lpopamp_core_0.sliceA_0.zp_m lpopamp_core_0.sliceA_0.zp_m avdd sg13_hv_pmos ad=1.125p pd=5u as=1.125p ps=5u w=4.5u l=0.5u
X2071 lpopamp_core_0.sliceB_1.yp_p lpopamp_core_0.sliceB_1.zp_m avdd avdd sg13_hv_pmos ad=1.125p pd=5u as=1.125p ps=5u w=4.5u l=3.5u
X2072 out zp_p avdd avdd sg13_hv_pmos ad=1.125p pd=5u as=1.125p ps=5u w=4.5u l=0.5u
X2073 a_14750_7150# in_m lpopamp_core_0.sliceB_0.yp_p avss sg13_hv_nmos ad=1.125p pd=5u as=1.125p ps=5u w=4.5u l=0.5u
X2074 a_23850_11850# lpopamp_core_0.sliceA_1.bpb lpopamp_core_0.sliceA_1.zn_m avdd sg13_hv_pmos ad=1.125p pd=5u as=1.125p ps=5u w=4.5u l=0.5u
X2075 lpopamp_core_0.sliceB_0.bnb lpopamp_core_0.sliceB_0.bnb a_11350_7150# avss sg13_hv_nmos ad=1.125p pd=5u as=1.125p ps=5u w=4.5u l=0.5u
X2076 lpopamp_core_0.sliceA_0.yp_m lpopamp_core_0.sliceA_0.zp_m zp_p avdd sg13_hv_pmos ad=1.125p pd=5u as=1.125p ps=5u w=4.5u l=0.5u
X2077 a_26350_100# lpopamp_core_0.sliceA_0.bnb zn_p avss sg13_hv_nmos ad=1.125p pd=5u as=1.125p ps=5u w=4.5u l=0.5u
X2078 lpopamp_core_0.sliceB_1.tihi lpopamp_core_0.sliceB_1.tihi avdd avdd sg13_hv_pmos ad=1.125p pd=5u as=1.125p ps=5u w=4.5u l=9.5u
X2079 lpopamp_core_0.sliceA_1.yn_p in_m lpopamp_core_0.sliceA_1.xp avdd sg13_hv_pmos ad=1.125p pd=5u as=1.125p ps=5u w=4.5u l=0.5u
X2080 lpopamp_core_0.sliceB_1.bpb lpopamp_core_0.sliceB_1.bna a_6850_8400# avss sg13_hv_nmos ad=1.125p pd=5u as=1.125p ps=5u w=4.5u l=3.5u
X2081 avss lpopamp_core_0.sliceA_1.bna a_7650_14250# avss sg13_hv_nmos ad=1.125p pd=5u as=1.125p ps=5u w=4.5u l=3.5u
X2082 lpopamp_core_0.sliceA_0.yp_p lpopamp_core_0.sliceA_0.zp_m lpopamp_core_0.sliceA_0.zp_m avdd sg13_hv_pmos ad=1.125p pd=5u as=1.125p ps=5u w=4.5u l=0.5u
X2083 zn_p lpopamp_core_0.sliceB_1.zn_m a_27350_8400# avss sg13_hv_nmos ad=1.125p pd=5u as=1.125p ps=5u w=4.5u l=0.5u
X2084 a_6050_7150# lpopamp_core_0.sliceB_0.bna lpopamp_core_0.sliceB_0.bpa avss sg13_hv_nmos ad=1.125p pd=5u as=1.125p ps=5u w=4.5u l=3.5u
X2085 a_21150_14850# lpopamp_core_0.sliceA_1.bnb lpopamp_core_0.sliceA_1.zp_m avss sg13_hv_nmos ad=1.125p pd=5u as=1.125p ps=5u w=4.5u l=0.5u
X2086 zp_p lpopamp_core_0.sliceA_1.zp_m lpopamp_core_0.sliceA_1.yp_m avdd sg13_hv_pmos ad=1.125p pd=5u as=1.125p ps=5u w=4.5u l=0.5u
X2087 a_24450_8400# lpopamp_core_0.sliceB_1.zn_m lpopamp_core_0.sliceB_1.yn_p avss sg13_hv_nmos ad=1.125p pd=5u as=1.125p ps=5u w=4.5u l=3.5u
X2088 lpopamp_core_0.sliceA_0.bnb lpopamp_core_0.sliceA_0.bnb a_11350_100# avss sg13_hv_nmos ad=1.125p pd=5u as=1.125p ps=5u w=4.5u l=0.5u
X2089 a_18850_100# lpopamp_core_0.sliceA_0.zn_m lpopamp_core_0.sliceA_0.yn_m avss sg13_hv_nmos ad=1.125p pd=5u as=1.125p ps=5u w=4.5u l=3.5u
X2090 lpopamp_core_0.sliceA_0.yn_p in_m lpopamp_core_0.sliceA_0.xp avdd sg13_hv_pmos ad=1.125p pd=5u as=1.125p ps=5u w=4.5u l=0.5u
X2091 a_29550_7150# zn_p out avss sg13_hv_nmos ad=1.125p pd=5u as=1.125p ps=5u w=4.5u l=0.5u
X2092 lpopamp_core_0.sliceA_1.bpb lpopamp_core_0.sliceA_1.bpb lpopamp_core_0.sliceA_1.bpa_l avdd sg13_hv_pmos ad=1.125p pd=5u as=1.125p ps=5u w=4.5u l=0.5u
X2093 a_14950_14850# in_p lpopamp_core_0.sliceA_1.xn avss sg13_hv_nmos ad=1.125p pd=5u as=1.125p ps=5u w=4.5u l=0.5u
X2094 a_20550_700# lpopamp_core_0.sliceA_0.bnb a_20050_100# avss sg13_hv_nmos ad=1.125p pd=5u as=1.125p ps=5u w=4.5u l=0.5u
X2095 lpopamp_core_0.sliceA_0.yn_m lpopamp_core_0.sliceA_0.zn_m a_27550_700# avss sg13_hv_nmos ad=1.125p pd=5u as=1.125p ps=5u w=4.5u l=0.5u
X2096 out zp_p a_28650_10800# avdd sg13_hv_pmos ad=1.125p pd=5u as=1.125p ps=5u w=4.5u l=0.5u
X2097 lpopamp_core_0.sliceB_0.xp lpopamp_core_0.sliceB_0.bpa avdd avdd sg13_hv_pmos ad=1.125p pd=5u as=1.125p ps=5u w=4.5u l=3.5u
X2098 zn_p lpopamp_core_0.sliceB_0.zn_m a_26150_7150# avss sg13_hv_nmos ad=1.125p pd=5u as=1.125p ps=5u w=4.5u l=0.5u
X2099 a_10950_4150# lpopamp_core_0.sliceB_0.bpa_r lpopamp_core_0.sliceB_0.bpa_r avdd sg13_hv_pmos ad=1.125p pd=5u as=1.125p ps=5u w=4.5u l=0.5u
X2100 lpopamp_core_0.sliceB_0.xp in_m lpopamp_core_0.sliceB_0.yn_p avdd sg13_hv_pmos ad=1.125p pd=5u as=1.125p ps=5u w=4.5u l=0.5u
X2101 a_11150_4750# lpopamp_core_0.sliceB_0.bpa_r a_11050_4750# avdd sg13_hv_pmos ad=1.125p pd=5u as=1.125p ps=5u w=4.5u l=0.5u
X2102 a_12150_7800# lpopamp_core_0.sliceB_1.bna_ lpopamp_core_0.sliceB_1.bna_ avss sg13_hv_nmos ad=1.125p pd=5u as=1.125p ps=5u w=4.5u l=0.5u
X2103 lpopamp_core_0.sliceB_0.yp_p lpopamp_core_0.sliceB_0.zp_m avdd avdd sg13_hv_pmos ad=1.125p pd=5u as=1.125p ps=5u w=4.5u l=3.5u
X2104 a_8750_700# lpopamp_core_0.sliceA_0.bna_ a_8650_700# avss sg13_hv_nmos ad=1.125p pd=5u as=1.125p ps=5u w=4.5u l=0.5u
X2105 lpopamp_core_0.sliceA_0.bpb lpopamp_core_0.sliceA_0.bpb lpopamp_core_0.sliceA_0.bpa_l avdd sg13_hv_pmos ad=1.125p pd=5u as=1.125p ps=5u w=4.5u l=0.5u
X2106 lpopamp_core_0.sliceB_0.yp_m in_p a_14150_6550# avss sg13_hv_nmos ad=1.125p pd=5u as=1.125p ps=5u w=4.5u l=0.5u
X2107 a_8550_10800# lpopamp_core_0.sliceB_1.bpa_l lpopamp_core_0.sliceB_1.bpa_l avdd sg13_hv_pmos ad=1.125p pd=5u as=1.125p ps=5u w=4.5u l=0.5u
X2108 a_12750_700# lpopamp_core_0.sliceA_0.bna_ a_12650_700# avss sg13_hv_nmos ad=1.125p pd=5u as=1.125p ps=5u w=4.5u l=0.5u
X2109 lpopamp_core_0.sliceA_1.bnb lpopamp_core_0.sliceA_1.bnb a_9750_14850# avss sg13_hv_nmos ad=1.125p pd=5u as=1.125p ps=5u w=4.5u l=0.5u
X2110 avdd lpopamp_core_0.sliceA_0.zp_m lpopamp_core_0.sliceA_0.yp_p avdd sg13_hv_pmos ad=1.125p pd=5u as=1.125p ps=5u w=4.5u l=3.5u
X2111 a_8750_4750# lpopamp_core_0.sliceB_0.bpa_l a_8650_4750# avdd sg13_hv_pmos ad=1.125p pd=5u as=1.125p ps=5u w=4.5u l=0.5u
X2112 zn_p lpopamp_core_0.sliceB_1.zn_m a_25750_7800# avss sg13_hv_nmos ad=1.125p pd=5u as=1.125p ps=5u w=4.5u l=0.5u
X2113 a_9750_7800# lpopamp_core_0.sliceB_1.bnb lpopamp_core_0.sliceB_1.bna_ avss sg13_hv_nmos ad=1.125p pd=5u as=1.125p ps=5u w=4.5u l=0.5u
X2114 avdd lpopamp_core_0.sliceB_1.zp_m lpopamp_core_0.sliceB_1.yp_p avdd sg13_hv_pmos ad=1.125p pd=5u as=1.125p ps=5u w=4.5u l=3.5u
X2115 lpopamp_core_0.sliceA_0.yp_m lpopamp_core_0.sliceA_0.zp_m zp_p avdd sg13_hv_pmos ad=1.125p pd=5u as=1.125p ps=5u w=4.5u l=0.5u
X2116 lpopamp_core_0.sliceB_1.bpb lpopamp_core_0.sliceB_1.bpb lpopamp_core_0.sliceB_1.bpa_r avdd sg13_hv_pmos ad=1.125p pd=5u as=1.125p ps=5u w=4.5u l=0.5u
X2117 lpopamp_core_0.sliceA_1.bnb lpopamp_core_0.sliceA_1.bnb a_11750_14250# avss sg13_hv_nmos ad=1.125p pd=5u as=1.125p ps=5u w=4.5u l=0.5u
X2118 zn_p lpopamp_core_0.sliceB_1.bpb zp_p avdd sg13_hv_pmos ad=1.125p pd=5u as=1.125p ps=5u w=4.5u l=0.5u
X2119 avdd lpopamp_core_0.sliceA_0.zp_m lpopamp_core_0.sliceA_0.yp_m avdd sg13_hv_pmos ad=1.125p pd=5u as=1.125p ps=5u w=4.5u l=3.5u
X2120 lpopamp_core_0.sliceB_0.zp_m lpopamp_core_0.sliceB_0.zp_m lpopamp_core_0.sliceB_0.yp_p avdd sg13_hv_pmos ad=1.125p pd=5u as=1.125p ps=5u w=4.5u l=0.5u
X2121 avss zn_p a_29950_7150# avss sg13_hv_nmos ad=1.125p pd=5u as=1.125p ps=5u w=4.5u l=0.5u
X2122 lpopamp_core_0.sliceB_1.yn_p lpopamp_core_0.sliceB_1.zn_m a_22450_7800# avss sg13_hv_nmos ad=1.125p pd=5u as=1.125p ps=5u w=4.5u l=3.5u
X2123 a_26950_14250# lpopamp_core_0.sliceA_1.bnb zp_p avss sg13_hv_nmos ad=1.125p pd=5u as=1.125p ps=5u w=4.5u l=0.5u
X2124 a_29150_700# zn_p out avss sg13_hv_nmos ad=1.125p pd=5u as=1.125p ps=5u w=4.5u l=0.5u
X2125 avss zn_p a_28750_100# avss sg13_hv_nmos ad=1.125p pd=5u as=1.125p ps=5u w=4.5u l=0.5u
X2126 avss lpopamp_core_0.sliceA_0.bna a_21650_100# avss sg13_hv_nmos ad=1.125p pd=5u as=1.125p ps=5u w=4.5u l=3.5u
X2127 avdd zp_p out avdd sg13_hv_pmos ad=1.125p pd=5u as=1.125p ps=5u w=4.5u l=0.5u
X2128 avss lpopamp_core_0.sliceA_1.bna a_15650_14250# avss sg13_hv_nmos ad=1.125p pd=5u as=1.125p ps=5u w=4.5u l=3.5u
X2129 out zp_p avdd avdd sg13_hv_pmos ad=1.125p pd=5u as=1.125p ps=5u w=4.5u l=0.5u
X2130 zp_p lpopamp_core_0.sliceB_0.bpb zn_p avdd sg13_hv_pmos ad=1.125p pd=5u as=1.125p ps=5u w=4.5u l=0.5u
X2131 lpopamp_core_0.sliceB_0.bpa_r lpopamp_core_0.sliceB_0.bpb lpopamp_core_0.sliceB_0.bpb avdd sg13_hv_pmos ad=1.125p pd=5u as=1.125p ps=5u w=4.5u l=0.5u
X2132 lpopamp_core_0.sliceB_1.yn_p in_m lpopamp_core_0.sliceB_1.xp avdd sg13_hv_pmos ad=1.125p pd=5u as=1.125p ps=5u w=4.5u l=0.5u
X2133 lpopamp_core_0.sliceB_0.enb en avdd avdd sg13_hv_pmos ad=1.125p pd=5u as=2.25p ps=10u w=4.5u l=1.5u
X2134 a_8550_6550# lpopamp_core_0.sliceB_0.bna_ a_8450_6550# avss sg13_hv_nmos ad=1.125p pd=5u as=1.125p ps=5u w=4.5u l=0.5u
X2135 lpopamp_core_0.sliceA_0.yp_p lpopamp_core_0.sliceA_0.zp_m avdd avdd sg13_hv_pmos ad=1.125p pd=5u as=1.125p ps=5u w=4.5u l=3.5u
X2136 a_21650_6550# lpopamp_core_0.sliceB_0.bna a_20050_6550# avss sg13_hv_nmos ad=1.125p pd=5u as=1.125p ps=5u w=4.5u l=3.5u
X2137 zp_p lpopamp_core_0.sliceA_1.zp_m lpopamp_core_0.sliceA_1.yp_m avdd sg13_hv_pmos ad=1.125p pd=5u as=1.125p ps=5u w=4.5u l=0.5u
X2138 out zn_p a_28950_6550# avss sg13_hv_nmos ad=1.125p pd=5u as=1.125p ps=5u w=4.5u l=0.5u
X2139 lpopamp_core_0.sliceA_1.xp lpopamp_core_0.sliceA_1.bpa avdd avdd sg13_hv_pmos ad=1.125p pd=5u as=1.125p ps=5u w=4.5u l=3.5u
X2140 a_9950_100# lpopamp_core_0.sliceA_0.bnb lpopamp_core_0.sliceA_0.bnb avss sg13_hv_nmos ad=1.125p pd=5u as=1.125p ps=5u w=4.5u l=0.5u
X2141 lpopamp_core_0.sliceA_0.yp_p in_m a_14150_700# avss sg13_hv_nmos ad=1.125p pd=5u as=1.125p ps=5u w=4.5u l=0.5u
X2142 a_13950_100# in_m lpopamp_core_0.sliceA_0.yp_p avss sg13_hv_nmos ad=1.125p pd=5u as=1.125p ps=5u w=4.5u l=0.5u
X2143 lpopamp_core_0.sliceB_1.bpb lpopamp_core_0.sliceB_1.bpb lpopamp_core_0.sliceB_1.bpa_r avdd sg13_hv_pmos ad=1.125p pd=5u as=1.125p ps=5u w=4.5u l=0.5u
X2144 out zp_p avdd avdd sg13_hv_pmos ad=1.125p pd=5u as=1.125p ps=5u w=4.5u l=0.5u
X2145 avdd zp_p out avdd sg13_hv_pmos ad=1.125p pd=5u as=1.125p ps=5u w=4.5u l=0.5u
X2146 lpopamp_core_0.sliceA_0.yn_p lpopamp_core_0.sliceA_0.zn_m a_23150_100# avss sg13_hv_nmos ad=1.125p pd=5u as=1.125p ps=5u w=4.5u l=0.5u
X2147 lpopamp_core_0.sliceB_0.bnb lpopamp_core_0.sliceB_0.bnb a_11750_7150# avss sg13_hv_nmos ad=1.125p pd=5u as=1.125p ps=5u w=4.5u l=0.5u
X2148 a_11050_11850# lpopamp_core_0.sliceA_1.bpa_r a_10950_11850# avdd sg13_hv_pmos ad=1.125p pd=5u as=1.125p ps=5u w=4.5u l=0.5u
X2149 a_20150_14850# lpopamp_core_0.sliceA_1.bnb a_20050_14250# avss sg13_hv_nmos ad=1.125p pd=5u as=1.125p ps=5u w=4.5u l=0.5u
X2150 zp_p lpopamp_core_0.sliceA_1.zp_m lpopamp_core_0.sliceA_1.yp_m avdd sg13_hv_pmos ad=1.125p pd=5u as=1.125p ps=5u w=4.5u l=0.5u
X2151 a_14150_8400# in_p lpopamp_core_0.sliceB_1.xn avss sg13_hv_nmos ad=1.125p pd=5u as=1.125p ps=5u w=4.5u l=0.5u
X2152 lpopamp_core_0.sliceA_1.bpb lpopamp_core_0.sliceA_1.bpb lpopamp_core_0.sliceA_1.bpa_l avdd sg13_hv_pmos ad=1.125p pd=5u as=1.125p ps=5u w=4.5u l=0.5u
X2153 avdd lpopamp_core_0.sliceA_0.bpa a_22450_2500# avdd sg13_hv_pmos ad=1.125p pd=5u as=1.125p ps=5u w=4.5u l=3.5u
X2154 a_13950_14850# in_m lpopamp_core_0.sliceA_1.yp_p avss sg13_hv_nmos ad=1.125p pd=5u as=1.125p ps=5u w=4.5u l=0.5u
X2155 lpopamp_core_0.sliceA_1.yn_p lpopamp_core_0.sliceA_1.zn_m a_23950_14850# avss sg13_hv_nmos ad=1.125p pd=5u as=1.125p ps=5u w=4.5u l=0.5u
X2156 lpopamp_core_0.sliceA_1.zp_m lpopamp_core_0.sliceA_1.zp_m lpopamp_core_0.sliceA_1.yp_p avdd sg13_hv_pmos ad=1.125p pd=5u as=1.125p ps=5u w=4.5u l=0.5u
X2157 zp_p lpopamp_core_0.sliceB_1.bpb zn_p avdd sg13_hv_pmos ad=1.125p pd=5u as=1.125p ps=5u w=4.5u l=0.5u
X2158 lpopamp_core_0.sliceA_0.bpa_l lpopamp_core_0.sliceA_0.bpb lpopamp_core_0.sliceA_0.bpb avdd sg13_hv_pmos ad=1.125p pd=5u as=1.125p ps=5u w=4.5u l=0.5u
X2159 lpopamp_core_0.sliceB_1.yn_m in_p lpopamp_core_0.sliceB_1.xp avdd sg13_hv_pmos ad=1.125p pd=5u as=1.125p ps=5u w=4.5u l=0.5u
X2160 avss lpopamp_core_0.sliceB_1.zn_m a_24450_8400# avss sg13_hv_nmos ad=1.125p pd=5u as=1.125p ps=5u w=4.5u l=3.5u
X2161 lpopamp_core_0.sliceA_0.yn_p in_m lpopamp_core_0.sliceA_0.xp avdd sg13_hv_pmos ad=1.125p pd=5u as=1.125p ps=5u w=4.5u l=0.5u
X2162 a_8450_8400# lpopamp_core_0.sliceB_1.bna_ a_8350_8400# avss sg13_hv_nmos ad=1.125p pd=5u as=1.125p ps=5u w=4.5u l=0.5u
X2163 a_29950_7150# zn_p out avss sg13_hv_nmos ad=1.125p pd=5u as=1.125p ps=5u w=4.5u l=0.5u
X2164 a_5250_14850# lpopamp_core_0.sliceA_1.bna avss avss sg13_hv_nmos ad=1.125p pd=5u as=1.125p ps=5u w=4.5u l=3.5u
X2165 a_20050_7800# lpopamp_core_0.sliceB_1.bnb a_21150_8400# avss sg13_hv_nmos ad=1.125p pd=5u as=1.125p ps=5u w=4.5u l=0.5u
X2166 avss lpopamp_core_0.sliceA_0.zn_m a_24450_700# avss sg13_hv_nmos ad=1.125p pd=5u as=1.125p ps=5u w=4.5u l=3.5u
X2167 zn_p lpopamp_core_0.sliceB_0.bnb a_26550_7150# avss sg13_hv_nmos ad=1.125p pd=5u as=1.125p ps=5u w=4.5u l=0.5u
X2168 lpopamp_core_0.sliceB_1.bpb lpopamp_core_0.sliceB_1.bpb lpopamp_core_0.sliceB_1.bpa_l avdd sg13_hv_pmos ad=1.125p pd=5u as=1.125p ps=5u w=4.5u l=0.5u
X2169 lpopamp_core_0.sliceA_1.bna_ lpopamp_core_0.sliceA_1.bna_ a_8750_14850# avss sg13_hv_nmos ad=1.125p pd=5u as=1.125p ps=5u w=4.5u l=0.5u
X2170 lpopamp_core_0.sliceA_0.bpb lpopamp_core_0.sliceA_0.bpb lpopamp_core_0.sliceA_0.bpa_r avdd sg13_hv_pmos ad=1.125p pd=5u as=1.125p ps=5u w=4.5u l=0.5u
X2171 lpopamp_core_0.sliceB_1.yp_p lpopamp_core_0.sliceB_1.zp_m avdd avdd sg13_hv_pmos ad=1.125p pd=5u as=1.125p ps=5u w=4.5u l=3.5u
X2172 a_23350_7150# lpopamp_core_0.sliceB_0.zn_m lpopamp_core_0.sliceB_0.yn_p avss sg13_hv_nmos ad=1.125p pd=5u as=1.125p ps=5u w=4.5u l=0.5u
X2173 lpopamp_core_0.sliceA_1.bna_ lpopamp_core_0.sliceA_1.bnb a_10750_14250# avss sg13_hv_nmos ad=1.125p pd=5u as=1.125p ps=5u w=4.5u l=0.5u
X2174 a_12550_7800# lpopamp_core_0.sliceB_1.bna_ a_12450_7800# avss sg13_hv_nmos ad=1.125p pd=5u as=1.125p ps=5u w=4.5u l=0.5u
X2175 a_25950_14250# lpopamp_core_0.sliceA_1.zn_m zn_p avss sg13_hv_nmos ad=1.125p pd=5u as=1.125p ps=5u w=4.5u l=0.5u
X2176 a_14750_14250# in_p lpopamp_core_0.sliceA_1.yp_m avss sg13_hv_nmos ad=1.125p pd=5u as=1.125p ps=5u w=4.5u l=0.5u
X2177 out zn_p a_29750_14250# avss sg13_hv_nmos ad=1.125p pd=5u as=1.125p ps=5u w=4.5u l=0.5u
X2178 out zp_p avdd avdd sg13_hv_pmos ad=1.125p pd=5u as=1.125p ps=5u w=4.5u l=0.5u
X2179 avdd lpopamp_core_0.sliceB_0.zp_m lpopamp_core_0.sliceB_0.yp_p avdd sg13_hv_pmos ad=1.125p pd=5u as=1.125p ps=5u w=4.5u l=3.5u
X2180 avdd lpopamp_core_0.sliceB_1.bpa lpopamp_core_0.sliceB_1.xp avdd sg13_hv_pmos ad=1.125p pd=5u as=1.125p ps=5u w=4.5u l=3.5u
X2181 lpopamp_core_0.sliceA_0.bpb lpopamp_core_0.sliceA_0.bpb lpopamp_core_0.sliceA_0.bpa_l avdd sg13_hv_pmos ad=1.125p pd=5u as=1.125p ps=5u w=4.5u l=0.5u
X2182 lpopamp_core_0.sliceB_0.yp_p in_m a_14550_6550# avss sg13_hv_nmos ad=1.125p pd=5u as=1.125p ps=5u w=4.5u l=0.5u
X2183 lpopamp_core_0.sliceA_0.yp_p lpopamp_core_0.sliceA_0.zp_m avdd avdd sg13_hv_pmos ad=1.125p pd=5u as=1.125p ps=5u w=4.5u l=3.5u
X2184 a_11350_6550# lpopamp_core_0.sliceB_0.bnb lpopamp_core_0.sliceB_0.bna_ avss sg13_hv_nmos ad=1.125p pd=5u as=1.125p ps=5u w=4.5u l=0.5u
X2185 avdd lpopamp_core_0.sliceA_1.bpa_r a_11150_12450# avdd sg13_hv_pmos ad=1.125p pd=5u as=1.125p ps=5u w=4.5u l=0.5u
X2186 avdd lpopamp_core_0.sliceA_1.zp_m lpopamp_core_0.sliceA_1.yp_m avdd sg13_hv_pmos ad=1.125p pd=5u as=1.125p ps=5u w=4.5u l=3.5u
X2187 lpopamp_core_0.sliceA_0.yn_m lpopamp_core_0.sliceA_0.zn_m a_25950_700# avss sg13_hv_nmos ad=1.125p pd=5u as=1.125p ps=5u w=4.5u l=0.5u
X2188 a_25750_100# lpopamp_core_0.sliceA_0.zn_m lpopamp_core_0.sliceA_0.yn_m avss sg13_hv_nmos ad=1.125p pd=5u as=1.125p ps=5u w=4.5u l=0.5u
X2189 a_22950_7800# lpopamp_core_0.sliceB_1.zn_m lpopamp_core_0.sliceB_1.yn_p avss sg13_hv_nmos ad=1.125p pd=5u as=1.125p ps=5u w=4.5u l=0.5u
X2190 a_9050_3100# lpopamp_core_0.sliceA_0.bpa_r a_8950_3100# avdd sg13_hv_pmos ad=1.125p pd=5u as=1.125p ps=5u w=4.5u l=0.5u
X2191 avdd zp_p out avdd sg13_hv_pmos ad=1.125p pd=5u as=1.125p ps=5u w=4.5u l=0.5u
X2192 a_6050_14250# lpopamp_core_0.sliceA_1.bna lpopamp_core_0.sliceA_1.bpa avss sg13_hv_nmos ad=1.125p pd=5u as=1.125p ps=5u w=4.5u l=3.5u
X2193 lpopamp_core_0.sliceB_0.tihi lpopamp_core_0.sliceB_0.tihi avdd avdd sg13_hv_pmos ad=1.125p pd=5u as=1.125p ps=5u w=4.5u l=9.5u
X2194 lpopamp_core_0.sliceB_1.bpb lpopamp_core_0.sliceB_1.bpb lpopamp_core_0.sliceB_1.bpa_l avdd sg13_hv_pmos ad=1.125p pd=5u as=1.125p ps=5u w=4.5u l=0.5u
X2195 a_8950_6550# lpopamp_core_0.sliceB_0.bnb lpopamp_core_0.sliceB_0.bna_ avss sg13_hv_nmos ad=1.125p pd=5u as=1.125p ps=5u w=4.5u l=0.5u
X2196 lpopamp_core_0.sliceB_1.bna en ib avss sg13_hv_nmos ad=1.125p pd=5u as=1.125p ps=5u w=4.5u l=1.5u
X2197 lpopamp_core_0.sliceA_1.bna_ lpopamp_core_0.sliceA_1.bnb a_9550_14250# avss sg13_hv_nmos ad=1.125p pd=5u as=1.125p ps=5u w=4.5u l=0.5u
X2198 lpopamp_core_0.sliceA_0.zp_m lpopamp_core_0.sliceA_0.zp_m lpopamp_core_0.sliceA_0.yp_p avdd sg13_hv_pmos ad=1.125p pd=5u as=1.125p ps=5u w=4.5u l=0.5u
X2199 a_22450_4150# lpopamp_core_0.sliceB_0.bpb lpopamp_core_0.sliceB_0.zn_m avdd sg13_hv_pmos ad=1.125p pd=5u as=1.125p ps=5u w=4.5u l=0.5u
X2200 a_6750_4150# lpopamp_core_0.sliceB_0.bpa_l a_6650_4150# avdd sg13_hv_pmos ad=1.125p pd=5u as=1.125p ps=5u w=4.5u l=0.5u
X2201 avdd lpopamp_core_0.sliceB_0.zp_m lpopamp_core_0.sliceB_0.yp_m avdd sg13_hv_pmos ad=1.125p pd=5u as=1.125p ps=5u w=4.5u l=3.5u
X2202 a_27350_7800# lpopamp_core_0.sliceB_1.zn_m lpopamp_core_0.sliceB_1.yn_m avss sg13_hv_nmos ad=1.125p pd=5u as=1.125p ps=5u w=4.5u l=0.5u
X2203 lpopamp_core_0.sliceA_1.yp_p lpopamp_core_0.sliceA_1.zp_m lpopamp_core_0.sliceA_1.zp_m avdd sg13_hv_pmos ad=1.125p pd=5u as=1.125p ps=5u w=4.5u l=0.5u
X2204 avss lpopamp_core_0.sliceB_0.bna a_21650_6550# avss sg13_hv_nmos ad=1.125p pd=5u as=1.125p ps=5u w=4.5u l=3.5u
X2205 avss lpopamp_core_0.sliceA_1.enb zn_p avss sg13_hv_nmos ad=2.25p pd=10u as=1.125p ps=5u w=4.5u l=1.5u
X2206 a_22450_4150# lpopamp_core_0.sliceB_0.bpb lpopamp_core_0.sliceB_0.zn_m avdd sg13_hv_pmos ad=1.125p pd=5u as=1.125p ps=5u w=4.5u l=0.5u
X2207 lpopamp_core_0.sliceA_1.bpa_r lpopamp_core_0.sliceA_1.bpb lpopamp_core_0.sliceA_1.bpb avdd sg13_hv_pmos ad=1.125p pd=5u as=1.125p ps=5u w=4.5u l=0.5u
X2208 out zn_p a_29350_6550# avss sg13_hv_nmos ad=1.125p pd=5u as=1.125p ps=5u w=4.5u l=0.5u
X2209 lpopamp_core_0.sliceB_1.yn_p lpopamp_core_0.sliceB_1.zn_m a_23950_7800# avss sg13_hv_nmos ad=1.125p pd=5u as=1.125p ps=5u w=4.5u l=0.5u
X2210 a_22450_10200# lpopamp_core_0.sliceB_1.bpb lpopamp_core_0.sliceB_1.zn_m avdd sg13_hv_pmos ad=1.125p pd=5u as=1.125p ps=5u w=4.5u l=0.5u
X2211 avss en lpopamp_core_0.sliceB_0.enb avss sg13_hv_nmos ad=1.125p pd=5u as=1.125p ps=5u w=4.5u l=1.5u
X2212 avdd lpopamp_core_0.sliceA_1.bpa lpopamp_core_0.sliceA_1.bpa avdd sg13_hv_pmos ad=1.125p pd=5u as=1.125p ps=5u w=4.5u l=3.5u
X2213 lpopamp_core_0.sliceB_0.yp_m lpopamp_core_0.sliceB_0.zp_m zp_p avdd sg13_hv_pmos ad=1.125p pd=5u as=1.125p ps=5u w=4.5u l=0.5u
X2214 a_13250_14850# lpopamp_core_0.sliceA_1.bna avss avss sg13_hv_nmos ad=1.125p pd=5u as=1.125p ps=5u w=4.5u l=3.5u
X2215 lpopamp_core_0.sliceA_1.zn_m lpopamp_core_0.sliceA_1.zn_m a_22950_14850# avss sg13_hv_nmos ad=1.125p pd=5u as=1.125p ps=5u w=4.5u l=0.5u
X2216 avdd lpopamp_core_0.sliceA_1.bpa lpopamp_core_0.sliceA_1.xp avdd sg13_hv_pmos ad=1.125p pd=5u as=1.125p ps=5u w=4.5u l=3.5u
X2217 a_29050_11850# zp_p out avdd sg13_hv_pmos ad=1.125p pd=5u as=1.125p ps=5u w=4.5u l=0.5u
X2218 lpopamp_core_0.sliceB_1.yp_m lpopamp_core_0.sliceB_1.zp_m avdd avdd sg13_hv_pmos ad=1.125p pd=5u as=1.125p ps=5u w=4.5u l=3.5u
X2219 a_11150_700# lpopamp_core_0.sliceA_0.bnb lpopamp_core_0.sliceA_0.bnb avss sg13_hv_nmos ad=1.125p pd=5u as=1.125p ps=5u w=4.5u l=0.5u
X2220 lpopamp_core_0.sliceA_0.bna_ lpopamp_core_0.sliceA_0.bnb a_10750_100# avss sg13_hv_nmos ad=1.125p pd=5u as=1.125p ps=5u w=4.5u l=0.5u
X2221 a_26150_6550# lpopamp_core_0.sliceB_0.zn_m lpopamp_core_0.sliceB_0.yn_m avss sg13_hv_nmos ad=1.125p pd=5u as=1.125p ps=5u w=4.5u l=0.5u
X2222 lpopamp_core_0.sliceA_0.yn_m lpopamp_core_0.sliceA_0.zn_m a_27150_100# avss sg13_hv_nmos ad=1.125p pd=5u as=1.125p ps=5u w=4.5u l=0.5u
X2223 a_20150_100# lpopamp_core_0.sliceA_0.bnb a_20050_100# avss sg13_hv_nmos ad=1.125p pd=5u as=1.125p ps=5u w=4.5u l=0.5u
X2224 a_14550_8400# in_m lpopamp_core_0.sliceB_1.xn avss sg13_hv_nmos ad=1.125p pd=5u as=1.125p ps=5u w=4.5u l=0.5u
X2225 a_23850_2500# lpopamp_core_0.sliceA_0.bpa avdd avdd sg13_hv_pmos ad=1.125p pd=5u as=1.125p ps=5u w=4.5u l=3.5u
X2226 lpopamp_core_0.sliceA_0.bpa_l lpopamp_core_0.sliceA_0.bpb lpopamp_core_0.sliceA_0.bpb avdd sg13_hv_pmos ad=1.125p pd=5u as=1.125p ps=5u w=4.5u l=0.5u
X2227 zp_p en avdd avdd sg13_hv_pmos ad=1.125p pd=5u as=1.125p ps=5u w=4.5u l=1.5u
X2228 lpopamp_core_0.sliceA_1.bpb lpopamp_core_0.sliceA_1.bpb lpopamp_core_0.sliceA_1.bpa_r avdd sg13_hv_pmos ad=1.125p pd=5u as=1.125p ps=5u w=4.5u l=0.5u
X2229 lpopamp_core_0.sliceB_1.bna_ lpopamp_core_0.sliceB_1.bnb a_11150_8400# avss sg13_hv_nmos ad=1.125p pd=5u as=1.125p ps=5u w=4.5u l=0.5u
X2230 a_6550_10800# lpopamp_core_0.sliceB_1.bpa_l avdd avdd sg13_hv_pmos ad=1.125p pd=5u as=1.125p ps=5u w=4.5u l=0.5u
X2231 lpopamp_core_0.sliceA_0.yp_p lpopamp_core_0.sliceA_0.zp_m lpopamp_core_0.sliceA_0.zp_m avdd sg13_hv_pmos ad=1.125p pd=5u as=1.125p ps=5u w=4.5u l=0.5u
X2232 lpopamp_core_0.sliceB_0.xn lpopamp_core_0.sliceB_0.bna a_13250_7150# avss sg13_hv_nmos ad=1.125p pd=5u as=1.125p ps=5u w=4.5u l=3.5u
X2233 a_8350_100# lpopamp_core_0.sliceA_0.bna_ a_8250_100# avss sg13_hv_nmos ad=1.125p pd=5u as=1.125p ps=5u w=4.5u l=0.5u
X2234 lpopamp_core_0.sliceB_1.bna_ lpopamp_core_0.sliceB_1.bna_ a_8750_8400# avss sg13_hv_nmos ad=1.125p pd=5u as=1.125p ps=5u w=4.5u l=0.5u
X2235 a_25250_8400# lpopamp_core_0.sliceB_1.zn_m avss avss sg13_hv_nmos ad=1.125p pd=5u as=1.125p ps=5u w=4.5u l=3.5u
X2236 lpopamp_core_0.sliceB_0.bna_ lpopamp_core_0.sliceB_0.bnb a_9950_7150# avss sg13_hv_nmos ad=1.125p pd=5u as=1.125p ps=5u w=4.5u l=0.5u
X2237 a_25250_14250# lpopamp_core_0.sliceA_1.zn_m avss avss sg13_hv_nmos ad=1.125p pd=5u as=1.125p ps=5u w=4.5u l=3.5u
X2238 a_12350_100# lpopamp_core_0.sliceA_0.bna_ a_12250_100# avss sg13_hv_nmos ad=1.125p pd=5u as=1.125p ps=5u w=4.5u l=0.5u
X2239 a_13750_14250# in_m lpopamp_core_0.sliceA_1.xn avss sg13_hv_nmos ad=1.125p pd=5u as=1.125p ps=5u w=4.5u l=0.5u
X2240 avss zn_p a_28750_14250# avss sg13_hv_nmos ad=1.125p pd=5u as=1.125p ps=5u w=4.5u l=0.5u
X2241 zp_p lpopamp_core_0.sliceB_1.bpb zn_p avdd sg13_hv_pmos ad=1.125p pd=5u as=1.125p ps=5u w=4.5u l=0.5u
X2242 a_28550_700# zn_p avss avss sg13_hv_nmos ad=1.125p pd=5u as=1.125p ps=5u w=4.5u l=0.5u
X2243 a_29350_8400# zn_p avss avss sg13_hv_nmos ad=1.125p pd=5u as=1.125p ps=5u w=4.5u l=0.5u
X2244 lpopamp_core_0.sliceA_0.bpb lpopamp_core_0.sliceA_0.bpb lpopamp_core_0.sliceA_0.bpa_r avdd sg13_hv_pmos ad=1.125p pd=5u as=1.125p ps=5u w=4.5u l=0.5u
X2245 a_23750_7150# lpopamp_core_0.sliceB_0.zn_m lpopamp_core_0.sliceB_0.yn_p avss sg13_hv_nmos ad=1.125p pd=5u as=1.125p ps=5u w=4.5u l=0.5u
X2246 lpopamp_core_0.sliceA_1.yp_p lpopamp_core_0.sliceA_1.zp_m lpopamp_core_0.sliceA_1.zp_m avdd sg13_hv_pmos ad=1.125p pd=5u as=1.125p ps=5u w=4.5u l=0.5u
X2247 lpopamp_core_0.sliceA_1.bpa_r lpopamp_core_0.sliceA_1.bpb lpopamp_core_0.sliceA_1.bpb avdd sg13_hv_pmos ad=1.125p pd=5u as=1.125p ps=5u w=4.5u l=0.5u
X2248 lpopamp_core_0.sliceA_0.xp in_p lpopamp_core_0.sliceA_0.yn_m avdd sg13_hv_pmos ad=1.125p pd=5u as=1.125p ps=5u w=4.5u l=0.5u
X2249 lpopamp_core_0.sliceB_1.yn_m lpopamp_core_0.sliceB_1.zn_m a_25950_8400# avss sg13_hv_nmos ad=1.125p pd=5u as=1.125p ps=5u w=4.5u l=0.5u
X2250 zp_p lpopamp_core_0.sliceA_1.zp_m lpopamp_core_0.sliceA_1.yp_m avdd sg13_hv_pmos ad=1.125p pd=5u as=1.125p ps=5u w=4.5u l=0.5u
X2251 a_13250_7800# lpopamp_core_0.sliceB_1.bna avss avss sg13_hv_nmos ad=1.125p pd=5u as=1.125p ps=5u w=4.5u l=3.5u
X2252 a_20050_6550# lpopamp_core_0.sliceB_0.bnb a_20350_7150# avss sg13_hv_nmos ad=1.125p pd=5u as=1.125p ps=5u w=4.5u l=0.5u
X2253 avdd lpopamp_core_0.sliceA_1.zp_m lpopamp_core_0.sliceA_1.yp_p avdd sg13_hv_pmos ad=1.125p pd=5u as=1.125p ps=5u w=4.5u l=3.5u
X2254 avdd zp_p out avdd sg13_hv_pmos ad=1.125p pd=5u as=1.125p ps=5u w=4.5u l=0.5u
X2255 avss lpopamp_core_0.sliceB_0.zn_m a_28050_7150# avss sg13_hv_nmos ad=1.125p pd=5u as=1.125p ps=5u w=4.5u l=3.5u
X2256 avss lpopamp_core_0.sliceA_1.enb lpopamp_core_0.sliceA_1.bna avss sg13_hv_nmos ad=1.125p pd=5u as=1.125p ps=5u w=4.5u l=1.5u
X2257 lpopamp_core_0.sliceA_0.bna_ lpopamp_core_0.sliceA_0.bnb a_9550_700# avss sg13_hv_nmos ad=1.125p pd=5u as=1.125p ps=5u w=4.5u l=0.5u
X2258 lpopamp_core_0.sliceB_1.bpb lpopamp_core_0.sliceB_1.bpb lpopamp_core_0.sliceB_1.bpa_l avdd sg13_hv_pmos ad=1.125p pd=5u as=1.125p ps=5u w=4.5u l=0.5u
X2259 a_2850_700# lpopamp_core_0.sliceA_0.bna avss avss sg13_hv_nmos ad=1.125p pd=5u as=1.125p ps=5u w=4.5u l=3.5u
X2260 a_8650_14250# lpopamp_core_0.sliceA_1.bna_ a_8550_14250# avss sg13_hv_nmos ad=1.125p pd=5u as=1.125p ps=5u w=4.5u l=0.5u
X2261 avss lpopamp_core_0.sliceB_1.zn_m a_17250_7800# avss sg13_hv_nmos ad=1.125p pd=5u as=1.125p ps=5u w=4.5u l=3.5u
X2262 lpopamp_core_0.sliceA_1.yp_p lpopamp_core_0.sliceA_1.zp_m lpopamp_core_0.sliceA_1.zp_m avdd sg13_hv_pmos ad=1.125p pd=5u as=1.125p ps=5u w=4.5u l=0.5u
X2263 a_11750_6550# lpopamp_core_0.sliceB_0.bnb lpopamp_core_0.sliceB_0.bna_ avss sg13_hv_nmos ad=1.125p pd=5u as=1.125p ps=5u w=4.5u l=0.5u
X2264 avdd zp_p out avdd sg13_hv_pmos ad=1.125p pd=5u as=1.125p ps=5u w=4.5u l=0.5u
X2265 lpopamp_core_0.sliceB_1.xn in_p a_13950_7800# avss sg13_hv_nmos ad=1.125p pd=5u as=1.125p ps=5u w=4.5u l=0.5u
X2266 lpopamp_core_0.sliceA_1.zn_m lpopamp_core_0.sliceA_1.bpb a_23850_11850# avdd sg13_hv_pmos ad=1.125p pd=5u as=1.125p ps=5u w=4.5u l=0.5u
X2267 a_29750_100# zn_p avss avss sg13_hv_nmos ad=1.125p pd=5u as=1.125p ps=5u w=4.5u l=0.5u
X2268 lpopamp_core_0.sliceB_0.xp in_p lpopamp_core_0.sliceB_0.yn_m avdd sg13_hv_pmos ad=1.125p pd=5u as=1.125p ps=5u w=4.5u l=0.5u
X2269 lpopamp_core_0.sliceB_1.bpa_r lpopamp_core_0.sliceB_1.bpb lpopamp_core_0.sliceB_1.bpb avdd sg13_hv_pmos ad=1.125p pd=5u as=1.125p ps=5u w=4.5u l=0.5u
X2270 zp_p lpopamp_core_0.sliceA_0.zp_m lpopamp_core_0.sliceA_0.yp_m avdd sg13_hv_pmos ad=1.125p pd=5u as=1.125p ps=5u w=4.5u l=0.5u
X2271 lpopamp_core_0.sliceA_0.bpa_r lpopamp_core_0.sliceA_0.bpb lpopamp_core_0.sliceA_0.bpb avdd sg13_hv_pmos ad=1.125p pd=5u as=1.125p ps=5u w=4.5u l=0.5u
X2272 a_11950_14850# lpopamp_core_0.sliceA_1.bnb lpopamp_core_0.sliceA_1.bnb avss sg13_hv_nmos ad=1.125p pd=5u as=1.125p ps=5u w=4.5u l=0.5u
X2273 lpopamp_core_0.sliceA_1.yp_m lpopamp_core_0.sliceA_1.zp_m zp_p avdd sg13_hv_pmos ad=1.125p pd=5u as=1.125p ps=5u w=4.5u l=0.5u
X2274 zp_p lpopamp_core_0.sliceB_1.bpb zn_p avdd sg13_hv_pmos ad=1.125p pd=5u as=1.125p ps=5u w=4.5u l=0.5u
X2275 a_16450_6550# lpopamp_core_0.sliceB_0.zn_m avss avss sg13_hv_nmos ad=1.125p pd=5u as=1.125p ps=5u w=4.5u l=3.5u
X2276 a_9050_12450# lpopamp_core_0.sliceA_1.bpa_r a_8950_12450# avdd sg13_hv_pmos ad=1.125p pd=5u as=1.125p ps=5u w=4.5u l=0.5u
X2277 lpopamp_core_0.sliceB_1.yp_p lpopamp_core_0.sliceB_1.zp_m avdd avdd sg13_hv_pmos ad=1.125p pd=5u as=1.125p ps=5u w=4.5u l=3.5u
X2278 avdd zp_p out avdd sg13_hv_pmos ad=1.125p pd=5u as=1.125p ps=5u w=4.5u l=0.5u
X2279 avdd lpopamp_core_0.sliceA_0.bpa lpopamp_core_0.sliceA_0.bpa avdd sg13_hv_pmos ad=1.125p pd=5u as=1.125p ps=5u w=4.5u l=3.5u
X2280 lpopamp_core_0.sliceB_0.yp_m lpopamp_core_0.sliceB_0.zp_m avdd avdd sg13_hv_pmos ad=1.125p pd=5u as=1.125p ps=5u w=4.5u l=3.5u
X2281 a_28050_7800# lpopamp_core_0.sliceB_1.zn_m lpopamp_core_0.sliceB_1.yn_m avss sg13_hv_nmos ad=1.125p pd=5u as=1.125p ps=5u w=4.5u l=3.5u
X2282 a_20050_14250# lpopamp_core_0.sliceA_1.bna a_19650_14850# avss sg13_hv_nmos ad=1.125p pd=5u as=1.125p ps=5u w=4.5u l=3.5u
X2283 lpopamp_core_0.sliceB_1.xp in_m lpopamp_core_0.sliceB_1.yn_p avdd sg13_hv_pmos ad=1.125p pd=5u as=1.125p ps=5u w=4.5u l=0.5u
X2284 lpopamp_core_0.sliceA_0.xp in_m lpopamp_core_0.sliceA_0.yn_p avdd sg13_hv_pmos ad=1.125p pd=5u as=1.125p ps=5u w=4.5u l=0.5u
X2285 lpopamp_core_0.sliceB_0.bpb lpopamp_core_0.sliceB_0.bpb lpopamp_core_0.sliceB_0.bpa_l avdd sg13_hv_pmos ad=1.125p pd=5u as=1.125p ps=5u w=4.5u l=0.5u
X2286 out zn_p a_29750_6550# avss sg13_hv_nmos ad=1.125p pd=5u as=1.125p ps=5u w=4.5u l=0.5u
X2287 a_8350_7800# lpopamp_core_0.sliceB_1.bna_ a_8250_7800# avss sg13_hv_nmos ad=1.125p pd=5u as=1.125p ps=5u w=4.5u l=0.5u
X2288 a_4050_100# lpopamp_core_0.sliceA_0.bna lpopamp_core_0.sliceA_0.bna avss sg13_hv_nmos ad=1.125p pd=5u as=1.125p ps=5u w=4.5u l=3.5u
X2289 zn_p lpopamp_core_0.sliceB_0.bpb zp_p avdd sg13_hv_pmos ad=1.125p pd=5u as=1.125p ps=5u w=4.5u l=0.5u
X2290 lpopamp_core_0.sliceA_0.xn in_p a_14750_100# avss sg13_hv_nmos ad=1.125p pd=5u as=1.125p ps=5u w=4.5u l=0.5u
X2291 lpopamp_core_0.sliceB_0.zp_m lpopamp_core_0.sliceB_0.zp_m lpopamp_core_0.sliceB_0.yp_p avdd sg13_hv_pmos ad=1.125p pd=5u as=1.125p ps=5u w=4.5u l=0.5u
X2292 a_21150_7800# lpopamp_core_0.sliceB_1.bnb lpopamp_core_0.sliceB_1.zp_m avss sg13_hv_nmos ad=1.125p pd=5u as=1.125p ps=5u w=4.5u l=0.5u
X2293 lpopamp_core_0.sliceA_1.bna lpopamp_core_0.sliceA_1.bna a_2850_14850# avss sg13_hv_nmos ad=1.125p pd=5u as=1.125p ps=5u w=4.5u l=3.5u
X2294 a_8950_11850# lpopamp_core_0.sliceA_1.bpa_r avdd avdd sg13_hv_pmos ad=1.125p pd=5u as=1.125p ps=5u w=4.5u l=0.5u
X2295 a_15150_700# in_p lpopamp_core_0.sliceA_0.yp_m avss sg13_hv_nmos ad=1.125p pd=5u as=1.125p ps=5u w=4.5u l=0.5u
X2296 a_26550_6550# lpopamp_core_0.sliceB_0.bnb zp_p avss sg13_hv_nmos ad=1.125p pd=5u as=1.125p ps=5u w=4.5u l=0.5u
X2297 a_23950_700# lpopamp_core_0.sliceA_0.zn_m lpopamp_core_0.sliceA_0.zn_m avss sg13_hv_nmos ad=1.125p pd=5u as=1.125p ps=5u w=4.5u l=0.5u
X2298 lpopamp_core_0.sliceB_0.zn_m lpopamp_core_0.sliceB_0.bpb a_23850_4150# avdd sg13_hv_pmos ad=1.125p pd=5u as=1.125p ps=5u w=4.5u l=0.5u
X2299 lpopamp_core_0.sliceB_0.bpa_l lpopamp_core_0.sliceB_0.bpb lpopamp_core_0.sliceB_0.bpb avdd sg13_hv_pmos ad=1.125p pd=5u as=1.125p ps=5u w=4.5u l=0.5u
X2300 lpopamp_core_0.sliceA_0.bpa_r lpopamp_core_0.sliceA_0.bpb lpopamp_core_0.sliceA_0.bpb avdd sg13_hv_pmos ad=1.125p pd=5u as=1.125p ps=5u w=4.5u l=0.5u
X2301 lpopamp_core_0.sliceB_0.yn_p lpopamp_core_0.sliceB_0.zn_m a_23150_6550# avss sg13_hv_nmos ad=1.125p pd=5u as=1.125p ps=5u w=4.5u l=0.5u
X2302 lpopamp_core_0.sliceB_1.bpa_r lpopamp_core_0.sliceB_1.bpb lpopamp_core_0.sliceB_1.bpb avdd sg13_hv_pmos ad=1.125p pd=5u as=1.125p ps=5u w=4.5u l=0.5u
X2303 zn_p lpopamp_core_0.sliceA_1.enb avss avss sg13_hv_nmos ad=1.125p pd=5u as=1.125p ps=5u w=4.5u l=1.5u
X2304 a_24450_100# lpopamp_core_0.sliceA_0.zn_m lpopamp_core_0.sliceA_0.yn_p avss sg13_hv_nmos ad=1.125p pd=5u as=1.125p ps=5u w=4.5u l=3.5u
X2305 a_22450_10200# lpopamp_core_0.sliceB_1.bpb lpopamp_core_0.sliceB_1.zn_m avdd sg13_hv_pmos ad=1.125p pd=5u as=1.125p ps=5u w=4.5u l=0.5u
X2306 a_14950_8400# in_m lpopamp_core_0.sliceB_1.xn avss sg13_hv_nmos ad=1.125p pd=5u as=1.125p ps=5u w=4.5u l=0.5u
X2307 a_23950_14250# lpopamp_core_0.sliceA_1.zn_m lpopamp_core_0.sliceA_1.zn_m avss sg13_hv_nmos ad=1.125p pd=5u as=1.125p ps=5u w=4.5u l=0.5u
X2308 a_12750_14250# lpopamp_core_0.sliceA_1.bna_ a_12650_14250# avss sg13_hv_nmos ad=1.125p pd=5u as=1.125p ps=5u w=4.5u l=0.5u
X2309 lpopamp_core_0.sliceA_0.zn_m lpopamp_core_0.sliceA_0.bpb a_23850_2500# avdd sg13_hv_pmos ad=1.125p pd=5u as=1.125p ps=5u w=4.5u l=0.5u
X2310 lpopamp_core_0.sliceB_1.bna_ lpopamp_core_0.sliceB_1.bnb a_11550_8400# avss sg13_hv_nmos ad=1.125p pd=5u as=1.125p ps=5u w=4.5u l=0.5u
X2311 lpopamp_core_0.sliceA_0.bpa_l lpopamp_core_0.sliceA_0.bpb lpopamp_core_0.sliceA_0.bpb avdd sg13_hv_pmos ad=1.125p pd=5u as=1.125p ps=5u w=4.5u l=0.5u
X2312 lpopamp_core_0.sliceB_1.yp_p lpopamp_core_0.sliceB_1.zp_m avdd avdd sg13_hv_pmos ad=1.125p pd=5u as=1.125p ps=5u w=4.5u l=3.5u
X2313 a_19650_8400# lpopamp_core_0.sliceB_1.bna avss avss sg13_hv_nmos ad=1.125p pd=5u as=1.125p ps=5u w=4.5u l=3.5u
X2314 lpopamp_core_0.sliceA_0.bpa en avdd avdd sg13_hv_pmos ad=1.125p pd=5u as=1.125p ps=5u w=4.5u l=1.5u
X2315 a_13750_7150# in_p lpopamp_core_0.sliceB_0.xn avss sg13_hv_nmos ad=1.125p pd=5u as=1.125p ps=5u w=4.5u l=0.5u
X2316 lpopamp_core_0.sliceA_1.zn_m lpopamp_core_0.sliceA_1.bpb a_23850_11850# avdd sg13_hv_pmos ad=1.125p pd=5u as=1.125p ps=5u w=4.5u l=0.5u
X2317 avss lpopamp_core_0.sliceB_0.enb zn_p avss sg13_hv_nmos ad=2.25p pd=10u as=1.125p ps=5u w=4.5u l=1.5u
X2318 lpopamp_core_0.sliceB_0.bna_ lpopamp_core_0.sliceB_0.bnb a_10350_7150# avss sg13_hv_nmos ad=1.125p pd=5u as=1.125p ps=5u w=4.5u l=0.5u
X2319 lpopamp_core_0.sliceB_0.yn_p lpopamp_core_0.sliceB_0.zn_m a_18050_7150# avss sg13_hv_nmos ad=1.125p pd=5u as=1.125p ps=5u w=4.5u l=3.5u
X2320 a_4050_14250# lpopamp_core_0.sliceA_1.bna lpopamp_core_0.sliceA_1.bna avss sg13_hv_nmos ad=1.125p pd=5u as=1.125p ps=5u w=4.5u l=3.5u
X2321 lpopamp_core_0.sliceA_1.xp in_m lpopamp_core_0.sliceA_1.yn_p avdd sg13_hv_pmos ad=1.125p pd=5u as=1.125p ps=5u w=4.5u l=0.5u
X2322 a_29750_8400# zn_p avss avss sg13_hv_nmos ad=1.125p pd=5u as=1.125p ps=5u w=4.5u l=0.5u
X2323 lpopamp_core_0.sliceA_0.xp in_p lpopamp_core_0.sliceA_0.yn_m avdd sg13_hv_pmos ad=1.125p pd=5u as=1.125p ps=5u w=4.5u l=0.5u
X2324 zp_p lpopamp_core_0.sliceB_1.bnb a_26350_8400# avss sg13_hv_nmos ad=1.125p pd=5u as=1.125p ps=5u w=4.5u l=0.5u
X2325 avdd lpopamp_core_0.sliceA_1.bpa a_22450_11850# avdd sg13_hv_pmos ad=1.125p pd=5u as=1.125p ps=5u w=4.5u l=3.5u
X2326 a_20050_6550# lpopamp_core_0.sliceB_0.bnb a_20750_7150# avss sg13_hv_nmos ad=1.125p pd=5u as=1.125p ps=5u w=4.5u l=0.5u
X2327 avss lpopamp_core_0.sliceB_0.enb lpopamp_core_0.sliceB_0.bna avss sg13_hv_nmos ad=1.125p pd=5u as=1.125p ps=5u w=4.5u l=1.5u
X2328 a_23150_8400# lpopamp_core_0.sliceB_1.zn_m lpopamp_core_0.sliceB_1.zn_m avss sg13_hv_nmos ad=1.125p pd=5u as=1.125p ps=5u w=4.5u l=0.5u
X2329 a_10950_14850# lpopamp_core_0.sliceA_1.bnb lpopamp_core_0.sliceA_1.bna_ avss sg13_hv_nmos ad=1.125p pd=5u as=1.125p ps=5u w=4.5u l=0.5u
X2330 lpopamp_core_0.sliceA_1.zp_m lpopamp_core_0.sliceA_1.bnb a_20950_14850# avss sg13_hv_nmos ad=1.125p pd=5u as=1.125p ps=5u w=4.5u l=0.5u
X2331 lpopamp_core_0.sliceA_1.yn_p in_m lpopamp_core_0.sliceA_1.xp avdd sg13_hv_pmos ad=1.125p pd=5u as=1.125p ps=5u w=4.5u l=0.5u
X2332 a_28550_7150# zn_p avss avss sg13_hv_nmos ad=1.125p pd=5u as=1.125p ps=5u w=4.5u l=0.5u
X2333 a_6850_700# lpopamp_core_0.sliceA_0.bna avss avss sg13_hv_nmos ad=1.125p pd=5u as=1.125p ps=5u w=4.5u l=3.5u
X2334 lpopamp_core_0.sliceA_1.bpa_l lpopamp_core_0.sliceA_1.bpb lpopamp_core_0.sliceA_1.bpb avdd sg13_hv_pmos ad=1.125p pd=5u as=1.125p ps=5u w=4.5u l=0.5u
X2335 lpopamp_core_0.sliceA_1.xn in_p a_14750_14850# avss sg13_hv_nmos ad=1.125p pd=5u as=1.125p ps=5u w=4.5u l=0.5u
X2336 a_28650_10800# zp_p out avdd sg13_hv_pmos ad=1.125p pd=5u as=1.125p ps=5u w=4.5u l=0.5u
X2337 a_10550_700# lpopamp_core_0.sliceA_0.bnb lpopamp_core_0.sliceA_0.bna_ avss sg13_hv_nmos ad=1.125p pd=5u as=1.125p ps=5u w=4.5u l=0.5u
X2338 lpopamp_core_0.sliceB_0.yn_m in_p lpopamp_core_0.sliceB_0.xp avdd sg13_hv_pmos ad=1.125p pd=5u as=1.125p ps=5u w=4.5u l=0.5u
X2339 a_18050_7800# lpopamp_core_0.sliceB_1.zn_m avss avss sg13_hv_nmos ad=1.125p pd=5u as=1.125p ps=5u w=4.5u l=3.5u
X2340 a_29950_14850# zn_p out avss sg13_hv_nmos ad=1.125p pd=5u as=1.125p ps=5u w=4.5u l=0.5u
X2341 a_9150_7150# lpopamp_core_0.sliceB_0.bnb lpopamp_core_0.sliceB_0.bnb avss sg13_hv_nmos ad=1.125p pd=5u as=1.125p ps=5u w=4.5u l=0.5u
X2342 lpopamp_core_0.sliceB_1.xn in_p a_14350_7800# avss sg13_hv_nmos ad=1.125p pd=5u as=1.125p ps=5u w=4.5u l=0.5u
X2343 zn_p lpopamp_core_0.sliceA_0.bnb a_26550_100# avss sg13_hv_nmos ad=1.125p pd=5u as=1.125p ps=5u w=4.5u l=0.5u
X2344 zp_p lpopamp_core_0.sliceA_0.bpb zn_p avdd sg13_hv_pmos ad=1.125p pd=5u as=1.125p ps=5u w=4.5u l=0.5u
X2345 lpopamp_core_0.sliceA_0.bpa_r lpopamp_core_0.sliceA_0.bpb lpopamp_core_0.sliceA_0.bpb avdd sg13_hv_pmos ad=1.125p pd=5u as=1.125p ps=5u w=4.5u l=0.5u
X2346 lpopamp_core_0.sliceB_0.bpb lpopamp_core_0.sliceB_0.bpb lpopamp_core_0.sliceB_0.bpa_r avdd sg13_hv_pmos ad=1.125p pd=5u as=1.125p ps=5u w=4.5u l=0.5u
X2347 a_11150_7800# lpopamp_core_0.sliceB_1.bnb lpopamp_core_0.sliceB_1.bnb avss sg13_hv_nmos ad=1.125p pd=5u as=1.125p ps=5u w=4.5u l=0.5u
X2348 lpopamp_core_0.sliceA_1.bpb lpopamp_core_0.sliceA_1.bpb lpopamp_core_0.sliceA_1.bpa_l avdd sg13_hv_pmos ad=1.125p pd=5u as=1.125p ps=5u w=4.5u l=0.5u
X2349 lpopamp_core_0.sliceB_0.yn_m lpopamp_core_0.sliceB_0.zn_m a_16450_6550# avss sg13_hv_nmos ad=1.125p pd=5u as=1.125p ps=5u w=4.5u l=3.5u
X2350 lpopamp_core_0.sliceB_1.bpa en avdd avdd sg13_hv_pmos ad=1.125p pd=5u as=1.125p ps=5u w=4.5u l=1.5u
X2351 a_22450_2500# lpopamp_core_0.sliceA_0.bpb lpopamp_core_0.sliceA_0.zn_m avdd sg13_hv_pmos ad=1.125p pd=5u as=1.125p ps=5u w=4.5u l=0.5u
X2352 a_6550_3100# lpopamp_core_0.sliceA_0.bpa_l avdd avdd sg13_hv_pmos ad=1.125p pd=5u as=1.125p ps=5u w=4.5u l=0.5u
X2353 a_9750_14850# lpopamp_core_0.sliceA_1.bnb lpopamp_core_0.sliceA_1.bna_ avss sg13_hv_nmos ad=1.125p pd=5u as=1.125p ps=5u w=4.5u l=0.5u
X2354 lpopamp_core_0.sliceB_1.bpa_l lpopamp_core_0.sliceB_1.bpb lpopamp_core_0.sliceB_1.bpb avdd sg13_hv_pmos ad=1.125p pd=5u as=1.125p ps=5u w=4.5u l=0.5u
X2355 a_11050_4150# lpopamp_core_0.sliceB_0.bpa_r a_10950_4150# avdd sg13_hv_pmos ad=1.125p pd=5u as=1.125p ps=5u w=4.5u l=0.5u
X2356 lpopamp_core_0.sliceB_0.bpb lpopamp_core_0.sliceB_0.bpb lpopamp_core_0.sliceB_0.bpa_l avdd sg13_hv_pmos ad=1.125p pd=5u as=1.125p ps=5u w=4.5u l=0.5u
X2357 a_8750_7800# lpopamp_core_0.sliceB_1.bna_ a_8650_7800# avss sg13_hv_nmos ad=1.125p pd=5u as=1.125p ps=5u w=4.5u l=0.5u
X2358 lpopamp_core_0.sliceB_1.yp_p lpopamp_core_0.sliceB_1.zp_m lpopamp_core_0.sliceB_1.zp_m avdd sg13_hv_pmos ad=1.125p pd=5u as=1.125p ps=5u w=4.5u l=0.5u
X2359 a_22950_14250# lpopamp_core_0.sliceA_1.zn_m lpopamp_core_0.sliceA_1.yn_p avss sg13_hv_nmos ad=1.125p pd=5u as=1.125p ps=5u w=4.5u l=0.5u
X2360 avss lpopamp_core_0.sliceA_0.bna a_7650_100# avss sg13_hv_nmos ad=1.125p pd=5u as=1.125p ps=5u w=4.5u l=3.5u
X2361 a_11750_14250# lpopamp_core_0.sliceA_1.bnb lpopamp_core_0.sliceA_1.bna_ avss sg13_hv_nmos ad=1.125p pd=5u as=1.125p ps=5u w=4.5u l=0.5u
X2362 lpopamp_core_0.sliceB_1.bpa_r lpopamp_core_0.sliceB_1.bpb lpopamp_core_0.sliceB_1.bpb avdd sg13_hv_pmos ad=1.125p pd=5u as=1.125p ps=5u w=4.5u l=0.5u
X2363 zp_p lpopamp_core_0.sliceB_1.zp_m lpopamp_core_0.sliceB_1.yp_m avdd sg13_hv_pmos ad=1.125p pd=5u as=1.125p ps=5u w=4.5u l=0.5u
X2364 zp_p lpopamp_core_0.sliceA_1.bnb a_26750_14250# avss sg13_hv_nmos ad=1.125p pd=5u as=1.125p ps=5u w=4.5u l=0.5u
X2365 lpopamp_core_0.sliceA_0.bna_ lpopamp_core_0.sliceA_0.bnb a_11950_700# avss sg13_hv_nmos ad=1.125p pd=5u as=1.125p ps=5u w=4.5u l=0.5u
X2366 a_11750_100# lpopamp_core_0.sliceA_0.bnb lpopamp_core_0.sliceA_0.bna_ avss sg13_hv_nmos ad=1.125p pd=5u as=1.125p ps=5u w=4.5u l=0.5u
X2367 a_26950_6550# lpopamp_core_0.sliceB_0.bnb zp_p avss sg13_hv_nmos ad=1.125p pd=5u as=1.125p ps=5u w=4.5u l=0.5u
X2368 avdd zp_p out avdd sg13_hv_pmos ad=1.125p pd=5u as=1.125p ps=5u w=4.5u l=0.5u
X2369 avss zn_p a_29150_7800# avss sg13_hv_nmos ad=1.125p pd=5u as=1.125p ps=5u w=4.5u l=0.5u
X2370 a_20050_100# lpopamp_core_0.sliceA_0.bnb a_20750_700# avss sg13_hv_nmos ad=1.125p pd=5u as=1.125p ps=5u w=4.5u l=0.5u
X2371 lpopamp_core_0.sliceA_0.bpa_r lpopamp_core_0.sliceA_0.bpb lpopamp_core_0.sliceA_0.bpb avdd sg13_hv_pmos ad=1.125p pd=5u as=1.125p ps=5u w=4.5u l=0.5u
X2372 a_8650_4150# lpopamp_core_0.sliceB_0.bpa_l a_8550_4150# avdd sg13_hv_pmos ad=1.125p pd=5u as=1.125p ps=5u w=4.5u l=0.5u
X2373 lpopamp_core_0.sliceB_1.xp in_m lpopamp_core_0.sliceB_1.yn_p avdd sg13_hv_pmos ad=1.125p pd=5u as=1.125p ps=5u w=4.5u l=0.5u
X2374 lpopamp_core_0.sliceB_0.yn_p lpopamp_core_0.sliceB_0.zn_m a_23550_6550# avss sg13_hv_nmos ad=1.125p pd=5u as=1.125p ps=5u w=4.5u l=0.5u
X2375 lpopamp_core_0.sliceB_1.enb en avss avss sg13_hv_nmos ad=1.125p pd=5u as=2.25p ps=10u w=4.5u l=1.5u
X2376 lpopamp_core_0.sliceA_0.yn_m in_p lpopamp_core_0.sliceA_0.xp avdd sg13_hv_pmos ad=1.125p pd=5u as=1.125p ps=5u w=4.5u l=0.5u
X2377 lpopamp_core_0.sliceB_0.yp_p lpopamp_core_0.sliceB_0.zp_m lpopamp_core_0.sliceB_0.zp_m avdd sg13_hv_pmos ad=1.125p pd=5u as=1.125p ps=5u w=4.5u l=0.5u
X2378 avdd lpopamp_core_0.sliceB_0.bpa lpopamp_core_0.sliceB_0.bpa avdd sg13_hv_pmos ad=1.125p pd=5u as=1.125p ps=5u w=4.5u l=3.5u
X2379 avss lpopamp_core_0.sliceA_0.zn_m a_28050_100# avss sg13_hv_nmos ad=1.125p pd=5u as=1.125p ps=5u w=4.5u l=3.5u
X2380 lpopamp_core_0.sliceA_0.zp_m lpopamp_core_0.sliceA_0.bnb a_20950_100# avss sg13_hv_nmos ad=1.125p pd=5u as=1.125p ps=5u w=4.5u l=0.5u
X2381 a_20350_6550# lpopamp_core_0.sliceB_0.bnb lpopamp_core_0.sliceB_0.zp_m avss sg13_hv_nmos ad=1.125p pd=5u as=1.125p ps=5u w=4.5u l=0.5u
X2382 out zp_p a_29050_4150# avdd sg13_hv_pmos ad=1.125p pd=5u as=1.125p ps=5u w=4.5u l=0.5u
X2383 lpopamp_core_0.sliceA_1.bnb lpopamp_core_0.sliceA_1.bpa avdd avdd sg13_hv_pmos ad=1.125p pd=5u as=1.125p ps=5u w=4.5u l=3.5u
X2384 zn_p lpopamp_core_0.sliceA_0.enb avss avss sg13_hv_nmos ad=1.125p pd=5u as=1.125p ps=5u w=4.5u l=1.5u
X2385 lpopamp_core_0.sliceA_1.yp_m lpopamp_core_0.sliceA_1.zp_m zp_p avdd sg13_hv_pmos ad=1.125p pd=5u as=1.125p ps=5u w=4.5u l=0.5u
X2386 avdd lpopamp_core_0.sliceB_1.bpa lpopamp_core_0.sliceB_1.bpa avdd sg13_hv_pmos ad=1.125p pd=5u as=1.125p ps=5u w=4.5u l=3.5u
X2387 a_20050_7800# lpopamp_core_0.sliceB_1.bna a_19650_8400# avss sg13_hv_nmos ad=1.125p pd=5u as=1.125p ps=5u w=4.5u l=3.5u
X2388 lpopamp_core_0.sliceA_0.bpa lpopamp_core_0.sliceA_0.bpa avdd avdd sg13_hv_pmos ad=1.125p pd=5u as=1.125p ps=5u w=4.5u l=3.5u
X2389 lpopamp_core_0.sliceB_1.bpa_r lpopamp_core_0.sliceB_1.bpa_r a_9150_10200# avdd sg13_hv_pmos ad=1.125p pd=5u as=1.125p ps=5u w=4.5u l=0.5u
X2390 out zp_p avdd avdd sg13_hv_pmos ad=1.125p pd=5u as=1.125p ps=5u w=4.5u l=0.5u
X2391 lpopamp_core_0.sliceA_0.enb en avss avss sg13_hv_nmos ad=1.125p pd=5u as=2.25p ps=10u w=4.5u l=1.5u
X2392 lpopamp_core_0.sliceA_0.bna_ lpopamp_core_0.sliceA_0.bnb a_9150_100# avss sg13_hv_nmos ad=1.125p pd=5u as=1.125p ps=5u w=4.5u l=0.5u
X2393 a_22450_11850# lpopamp_core_0.sliceA_1.bpa avdd avdd sg13_hv_pmos ad=1.125p pd=5u as=1.125p ps=5u w=4.5u l=3.5u
X2394 lpopamp_core_0.sliceB_0.bna_ lpopamp_core_0.sliceB_0.bnb a_10750_7150# avss sg13_hv_nmos ad=1.125p pd=5u as=1.125p ps=5u w=4.5u l=0.5u
X2395 lpopamp_core_0.sliceA_0.yp_m lpopamp_core_0.sliceA_0.zp_m zp_p avdd sg13_hv_pmos ad=1.125p pd=5u as=1.125p ps=5u w=4.5u l=0.5u
X2396 lpopamp_core_0.sliceA_0.bpb lpopamp_core_0.sliceA_0.bpb lpopamp_core_0.sliceA_0.bpa_r avdd sg13_hv_pmos ad=1.125p pd=5u as=1.125p ps=5u w=4.5u l=0.5u
X2397 lpopamp_core_0.sliceA_1.yp_m lpopamp_core_0.sliceA_1.zp_m zp_p avdd sg13_hv_pmos ad=1.125p pd=5u as=1.125p ps=5u w=4.5u l=0.5u
X2398 out zn_p a_29350_700# avss sg13_hv_nmos ad=1.125p pd=5u as=1.125p ps=5u w=4.5u l=0.5u
X2399 a_18850_7150# lpopamp_core_0.sliceB_0.zn_m lpopamp_core_0.sliceB_0.yn_p avss sg13_hv_nmos ad=1.125p pd=5u as=1.125p ps=5u w=4.5u l=3.5u
X2400 lpopamp_core_0.sliceA_1.bpa_l lpopamp_core_0.sliceA_1.bpb lpopamp_core_0.sliceA_1.bpb avdd sg13_hv_pmos ad=1.125p pd=5u as=1.125p ps=5u w=4.5u l=0.5u
X2401 avdd lpopamp_core_0.sliceB_1.bpa lpopamp_core_0.sliceB_1.bnb avdd sg13_hv_pmos ad=1.125p pd=5u as=1.125p ps=5u w=4.5u l=3.5u
X2402 a_22450_2500# lpopamp_core_0.sliceA_0.bpa avdd avdd sg13_hv_pmos ad=1.125p pd=5u as=1.125p ps=5u w=4.5u l=3.5u
X2403 lpopamp_core_0.sliceA_1.yp_p in_m a_13750_14850# avss sg13_hv_nmos ad=1.125p pd=5u as=1.125p ps=5u w=4.5u l=0.5u
X2404 lpopamp_core_0.sliceA_1.yp_p lpopamp_core_0.sliceA_1.zp_m lpopamp_core_0.sliceA_1.zp_m avdd sg13_hv_pmos ad=1.125p pd=5u as=1.125p ps=5u w=4.5u l=0.5u
X2405 zn_p lpopamp_core_0.sliceB_1.bpb zp_p avdd sg13_hv_pmos ad=1.125p pd=5u as=1.125p ps=5u w=4.5u l=0.5u
X2406 a_28950_14850# zn_p avss avss sg13_hv_nmos ad=1.125p pd=5u as=1.125p ps=5u w=4.5u l=0.5u
X2407 lpopamp_core_0.sliceB_0.xn in_m a_15150_7150# avss sg13_hv_nmos ad=1.125p pd=5u as=1.125p ps=5u w=4.5u l=0.5u
X2408 a_18050_14850# lpopamp_core_0.sliceA_1.zn_m avss avss sg13_hv_nmos ad=1.125p pd=5u as=1.125p ps=5u w=4.5u l=3.5u
X2409 zp_p lpopamp_core_0.sliceB_1.bnb a_26750_8400# avss sg13_hv_nmos ad=1.125p pd=5u as=1.125p ps=5u w=4.5u l=0.5u
X2410 a_23550_8400# lpopamp_core_0.sliceB_1.zn_m lpopamp_core_0.sliceB_1.zn_m avss sg13_hv_nmos ad=1.125p pd=5u as=1.125p ps=5u w=4.5u l=0.5u
X2411 a_28950_7150# zn_p avss avss sg13_hv_nmos ad=1.125p pd=5u as=1.125p ps=5u w=4.5u l=0.5u
X2412 lpopamp_core_0.sliceA_1.bpb lpopamp_core_0.sliceA_1.bpb lpopamp_core_0.sliceA_1.bpa_l avdd sg13_hv_pmos ad=1.125p pd=5u as=1.125p ps=5u w=4.5u l=0.5u
X2413 avdd lpopamp_core_0.sliceB_1.tihi lpopamp_core_0.sliceB_1.tihi avdd sg13_hv_pmos ad=1.125p pd=5u as=1.125p ps=5u w=4.5u l=9.5u
X2414 lpopamp_core_0.sliceB_1.zp_m lpopamp_core_0.sliceB_1.bnb a_20150_8400# avss sg13_hv_nmos ad=1.125p pd=5u as=1.125p ps=5u w=4.5u l=0.5u
X2415 a_14550_700# in_p lpopamp_core_0.sliceA_0.xn avss sg13_hv_nmos ad=1.125p pd=5u as=1.125p ps=5u w=4.5u l=0.5u
X2416 avss lpopamp_core_0.sliceB_1.bna a_4050_8400# avss sg13_hv_nmos ad=1.125p pd=5u as=1.125p ps=5u w=4.5u l=3.5u
X2417 a_9550_7150# lpopamp_core_0.sliceB_0.bnb lpopamp_core_0.sliceB_0.bnb avss sg13_hv_nmos ad=1.125p pd=5u as=1.125p ps=5u w=4.5u l=0.5u
X2418 a_8750_14850# lpopamp_core_0.sliceA_1.bna_ a_8650_14850# avss sg13_hv_nmos ad=1.125p pd=5u as=1.125p ps=5u w=4.5u l=0.5u
X2419 lpopamp_core_0.sliceB_1.bpa_l lpopamp_core_0.sliceB_1.bpb lpopamp_core_0.sliceB_1.bpb avdd sg13_hv_pmos ad=1.125p pd=5u as=1.125p ps=5u w=4.5u l=0.5u
X2420 lpopamp_core_0.sliceB_1.xn in_m a_14750_7800# avss sg13_hv_nmos ad=1.125p pd=5u as=1.125p ps=5u w=4.5u l=0.5u
X2421 a_23550_100# lpopamp_core_0.sliceA_0.zn_m lpopamp_core_0.sliceA_0.zn_m avss sg13_hv_nmos ad=1.125p pd=5u as=1.125p ps=5u w=4.5u l=0.5u
X2422 lpopamp_core_0.sliceA_0.xp in_m lpopamp_core_0.sliceA_0.yn_p avdd sg13_hv_pmos ad=1.125p pd=5u as=1.125p ps=5u w=4.5u l=0.5u
X2423 a_10750_14250# lpopamp_core_0.sliceA_1.bnb lpopamp_core_0.sliceA_1.bnb avss sg13_hv_nmos ad=1.125p pd=5u as=1.125p ps=5u w=4.5u l=0.5u
X2424 avdd lpopamp_core_0.sliceB_1.bpa a_23850_10200# avdd sg13_hv_pmos ad=1.125p pd=5u as=1.125p ps=5u w=4.5u l=3.5u
X2425 lpopamp_core_0.sliceB_0.bpb lpopamp_core_0.sliceB_0.bpb lpopamp_core_0.sliceB_0.bpa_r avdd sg13_hv_pmos ad=1.125p pd=5u as=1.125p ps=5u w=4.5u l=0.5u
X2426 a_11550_7800# lpopamp_core_0.sliceB_1.bnb lpopamp_core_0.sliceB_1.bnb avss sg13_hv_nmos ad=1.125p pd=5u as=1.125p ps=5u w=4.5u l=0.5u
X2427 zn_p lpopamp_core_0.sliceA_1.zn_m a_25750_14250# avss sg13_hv_nmos ad=1.125p pd=5u as=1.125p ps=5u w=4.5u l=0.5u
X2428 a_17250_6550# lpopamp_core_0.sliceB_0.zn_m lpopamp_core_0.sliceB_0.yn_m avss sg13_hv_nmos ad=1.125p pd=5u as=1.125p ps=5u w=4.5u l=3.5u
X2429 avdd lpopamp_core_0.sliceB_1.zp_m lpopamp_core_0.sliceB_1.yp_m avdd sg13_hv_pmos ad=1.125p pd=5u as=1.125p ps=5u w=4.5u l=3.5u
X2430 lpopamp_core_0.sliceA_1.yp_m in_p a_14550_14250# avss sg13_hv_nmos ad=1.125p pd=5u as=1.125p ps=5u w=4.5u l=0.5u
X2431 lpopamp_core_0.sliceB_0.xp in_m lpopamp_core_0.sliceB_0.yn_p avdd sg13_hv_pmos ad=1.125p pd=5u as=1.125p ps=5u w=4.5u l=0.5u
X2432 a_29750_14250# zn_p avss avss sg13_hv_nmos ad=1.125p pd=5u as=1.125p ps=5u w=4.5u l=0.5u
X2433 lpopamp_core_0.sliceA_0.bpb lpopamp_core_0.sliceA_0.bpb lpopamp_core_0.sliceA_0.bpa_l avdd sg13_hv_pmos ad=1.125p pd=5u as=1.125p ps=5u w=4.5u l=0.5u
X2434 a_18850_14250# lpopamp_core_0.sliceA_1.zn_m lpopamp_core_0.sliceA_1.yn_m avss sg13_hv_nmos ad=1.125p pd=5u as=1.125p ps=5u w=4.5u l=3.5u
X2435 lpopamp_core_0.sliceB_1.xp in_p lpopamp_core_0.sliceB_1.yn_m avdd sg13_hv_pmos ad=1.125p pd=5u as=1.125p ps=5u w=4.5u l=0.5u
X2436 a_10350_6550# lpopamp_core_0.sliceB_0.bnb lpopamp_core_0.sliceB_0.bnb avss sg13_hv_nmos ad=1.125p pd=5u as=1.125p ps=5u w=4.5u l=0.5u
X2437 zn_p lpopamp_core_0.sliceA_0.bpb zp_p avdd sg13_hv_pmos ad=1.125p pd=5u as=1.125p ps=5u w=4.5u l=0.5u
X2438 a_11150_12450# lpopamp_core_0.sliceA_1.bpa_r a_11050_12450# avdd sg13_hv_pmos ad=1.125p pd=5u as=1.125p ps=5u w=4.5u l=0.5u
X2439 lpopamp_core_0.sliceA_1.yp_m lpopamp_core_0.sliceA_1.zp_m zp_p avdd sg13_hv_pmos ad=1.125p pd=5u as=1.125p ps=5u w=4.5u l=0.5u
X2440 avss lpopamp_core_0.sliceA_0.bna a_15650_100# avss sg13_hv_nmos ad=1.125p pd=5u as=1.125p ps=5u w=4.5u l=3.5u
X2441 lpopamp_core_0.sliceA_0.zn_m lpopamp_core_0.sliceA_0.bpb a_23850_2500# avdd sg13_hv_pmos ad=1.125p pd=5u as=1.125p ps=5u w=4.5u l=0.5u
X2442 lpopamp_core_0.sliceA_0.bpa_l lpopamp_core_0.sliceA_0.bpb lpopamp_core_0.sliceA_0.bpb avdd sg13_hv_pmos ad=1.125p pd=5u as=1.125p ps=5u w=4.5u l=0.5u
X2443 avdd zp_p out avdd sg13_hv_pmos ad=1.125p pd=5u as=1.125p ps=5u w=4.5u l=0.5u
X2444 avss zn_p a_29550_7800# avss sg13_hv_nmos ad=1.125p pd=5u as=1.125p ps=5u w=4.5u l=0.5u
X2445 a_2850_7800# lpopamp_core_0.sliceB_1.bna avss avss sg13_hv_nmos ad=1.125p pd=5u as=1.125p ps=5u w=4.5u l=3.5u
X2446 lpopamp_core_0.sliceB_1.bpa_l lpopamp_core_0.sliceB_1.bpb lpopamp_core_0.sliceB_1.bpb avdd sg13_hv_pmos ad=1.125p pd=5u as=1.125p ps=5u w=4.5u l=0.5u
X2447 a_9550_14250# lpopamp_core_0.sliceA_1.bnb lpopamp_core_0.sliceA_1.bnb avss sg13_hv_nmos ad=1.125p pd=5u as=1.125p ps=5u w=4.5u l=0.5u
X2448 lpopamp_core_0.sliceA_0.yn_m in_p lpopamp_core_0.sliceA_0.xp avdd sg13_hv_pmos ad=1.125p pd=5u as=1.125p ps=5u w=4.5u l=0.5u
X2449 zp_p lpopamp_core_0.sliceB_0.zp_m lpopamp_core_0.sliceB_0.yp_m avdd sg13_hv_pmos ad=1.125p pd=5u as=1.125p ps=5u w=4.5u l=0.5u
X2450 lpopamp_core_0.sliceB_0.bpa_r lpopamp_core_0.sliceB_0.bpa_r a_9150_4750# avdd sg13_hv_pmos ad=1.125p pd=5u as=1.125p ps=5u w=4.5u l=0.5u
X2451 a_26350_7800# lpopamp_core_0.sliceB_1.bnb zn_p avss sg13_hv_nmos ad=1.125p pd=5u as=1.125p ps=5u w=4.5u l=0.5u
X2452 lpopamp_core_0.sliceB_0.bpa lpopamp_core_0.sliceB_0.bpa avdd avdd sg13_hv_pmos ad=1.125p pd=5u as=1.125p ps=5u w=4.5u l=3.5u
X2453 a_20750_6550# lpopamp_core_0.sliceB_0.bnb lpopamp_core_0.sliceB_0.zp_m avss sg13_hv_nmos ad=1.125p pd=5u as=1.125p ps=5u w=4.5u l=0.5u
X2454 lpopamp_core_0.sliceA_1.zp_m lpopamp_core_0.sliceA_1.zp_m lpopamp_core_0.sliceA_1.yp_p avdd sg13_hv_pmos ad=1.125p pd=5u as=1.125p ps=5u w=4.5u l=0.5u
X2455 out zp_p a_29450_4150# avdd sg13_hv_pmos ad=1.125p pd=5u as=1.125p ps=5u w=4.5u l=0.5u
X2456 lpopamp_core_0.sliceB_1.zn_m lpopamp_core_0.sliceB_1.zn_m a_22950_7800# avss sg13_hv_nmos ad=1.125p pd=5u as=1.125p ps=5u w=4.5u l=0.5u
X2457 lpopamp_core_0.sliceA_1.enb en avdd avdd sg13_hv_pmos ad=1.125p pd=5u as=2.25p ps=10u w=4.5u l=1.5u
X2458 avdd lpopamp_core_0.sliceA_1.zp_m lpopamp_core_0.sliceA_1.yp_m avdd sg13_hv_pmos ad=1.125p pd=5u as=1.125p ps=5u w=4.5u l=3.5u
X2459 lpopamp_core_0.sliceB_1.zn_m lpopamp_core_0.sliceB_1.bpb a_22450_10200# avdd sg13_hv_pmos ad=1.125p pd=5u as=1.125p ps=5u w=4.5u l=0.5u
X2460 lpopamp_core_0.sliceB_0.yp_m lpopamp_core_0.sliceB_0.zp_m zp_p avdd sg13_hv_pmos ad=1.125p pd=5u as=1.125p ps=5u w=4.5u l=0.5u
X2461 lpopamp_core_0.sliceA_0.bnb lpopamp_core_0.sliceA_0.bpa avdd avdd sg13_hv_pmos ad=1.125p pd=5u as=1.125p ps=5u w=4.5u l=3.5u
X2462 avss lpopamp_core_0.sliceA_1.bna_ a_12750_14850# avss sg13_hv_nmos ad=1.125p pd=5u as=1.125p ps=5u w=4.5u l=0.5u
X2463 lpopamp_core_0.sliceA_1.xp in_p lpopamp_core_0.sliceA_1.yn_m avdd sg13_hv_pmos ad=1.125p pd=5u as=1.125p ps=5u w=4.5u l=0.5u
X2464 lpopamp_core_0.sliceB_0.bnb lpopamp_core_0.sliceB_0.bnb a_8950_6550# avss sg13_hv_nmos ad=1.125p pd=5u as=1.125p ps=5u w=4.5u l=0.5u
X2465 lpopamp_core_0.sliceB_1.yp_p lpopamp_core_0.sliceB_1.zp_m avdd avdd sg13_hv_pmos ad=1.125p pd=5u as=1.125p ps=5u w=4.5u l=3.5u
X2466 avss lpopamp_core_0.sliceA_0.bna a_6050_100# avss sg13_hv_nmos ad=1.125p pd=5u as=1.125p ps=5u w=4.5u l=3.5u
X2467 zn_p lpopamp_core_0.sliceA_0.bpb zp_p avdd sg13_hv_pmos ad=1.125p pd=5u as=1.125p ps=5u w=4.5u l=0.5u
X2468 a_10150_100# lpopamp_core_0.sliceA_0.bnb lpopamp_core_0.sliceA_0.bna_ avss sg13_hv_nmos ad=1.125p pd=5u as=1.125p ps=5u w=4.5u l=0.5u
X2469 lpopamp_core_0.sliceA_0.bpb lpopamp_core_0.sliceA_0.bpb lpopamp_core_0.sliceA_0.bpa_r avdd sg13_hv_pmos ad=1.125p pd=5u as=1.125p ps=5u w=4.5u l=0.5u
X2470 avss lpopamp_core_0.sliceB_0.zn_m a_18850_7150# avss sg13_hv_nmos ad=1.125p pd=5u as=1.125p ps=5u w=4.5u l=3.5u
X2471 a_26350_700# lpopamp_core_0.sliceA_0.bnb zn_p avss sg13_hv_nmos ad=1.125p pd=5u as=1.125p ps=5u w=4.5u l=0.5u
X2472 lpopamp_core_0.sliceA_0.zn_m lpopamp_core_0.sliceA_0.bpb a_22450_2500# avdd sg13_hv_pmos ad=1.125p pd=5u as=1.125p ps=5u w=4.5u l=0.5u
X2473 zn_p lpopamp_core_0.sliceB_1.enb avss avss sg13_hv_nmos ad=1.125p pd=5u as=1.125p ps=5u w=4.5u l=1.5u
X2474 lpopamp_core_0.sliceB_1.tihi lpopamp_core_0.sliceB_1.tihi avdd avdd sg13_hv_pmos ad=1.125p pd=5u as=1.125p ps=5u w=4.5u l=9.5u
X2475 lpopamp_core_0.sliceB_1.bnb lpopamp_core_0.sliceB_1.bnb a_10150_8400# avss sg13_hv_nmos ad=1.125p pd=5u as=1.125p ps=5u w=4.5u l=0.5u
X2476 lpopamp_core_0.sliceA_1.bpa_r lpopamp_core_0.sliceA_1.bpb lpopamp_core_0.sliceA_1.bpb avdd sg13_hv_pmos ad=1.125p pd=5u as=1.125p ps=5u w=4.5u l=0.5u
X2477 avss lpopamp_core_0.sliceA_1.bna a_7650_14850# avss sg13_hv_nmos ad=1.125p pd=5u as=1.125p ps=5u w=4.5u l=3.5u
X2478 a_12350_7150# lpopamp_core_0.sliceB_0.bna_ a_12250_7150# avss sg13_hv_nmos ad=1.125p pd=5u as=1.125p ps=5u w=4.5u l=0.5u
X2479 a_20950_14250# lpopamp_core_0.sliceA_1.bnb a_20050_14250# avss sg13_hv_nmos ad=1.125p pd=5u as=1.125p ps=5u w=4.5u l=0.5u
X2480 avdd zp_p out avdd sg13_hv_pmos ad=1.125p pd=5u as=1.125p ps=5u w=4.5u l=0.5u
X2481 a_23850_10200# lpopamp_core_0.sliceB_1.bpa avdd avdd sg13_hv_pmos ad=1.125p pd=5u as=1.125p ps=5u w=4.5u l=3.5u
X2482 a_23950_8400# lpopamp_core_0.sliceB_1.zn_m lpopamp_core_0.sliceB_1.zn_m avss sg13_hv_nmos ad=1.125p pd=5u as=1.125p ps=5u w=4.5u l=0.5u
X2483 zn_p lpopamp_core_0.sliceB_1.bpb zp_p avdd sg13_hv_pmos ad=1.125p pd=5u as=1.125p ps=5u w=4.5u l=0.5u
X2484 a_28750_14250# zn_p out avss sg13_hv_nmos ad=1.125p pd=5u as=1.125p ps=5u w=4.5u l=0.5u
X2485 lpopamp_core_0.sliceB_1.bna lpopamp_core_0.sliceB_1.enb avss avss sg13_hv_nmos ad=1.125p pd=5u as=1.125p ps=5u w=4.5u l=1.5u
X2486 lpopamp_core_0.sliceB_1.zp_m lpopamp_core_0.sliceB_1.bnb a_20550_8400# avss sg13_hv_nmos ad=1.125p pd=5u as=1.125p ps=5u w=4.5u l=0.5u
X2487 lpopamp_core_0.sliceA_0.bnb lpopamp_core_0.sliceA_0.bnb a_11350_700# avss sg13_hv_nmos ad=1.125p pd=5u as=1.125p ps=5u w=4.5u l=0.5u
X2488 a_18850_700# lpopamp_core_0.sliceA_0.zn_m lpopamp_core_0.sliceA_0.yn_m avss sg13_hv_nmos ad=1.125p pd=5u as=1.125p ps=5u w=4.5u l=3.5u
X2489 a_9950_7150# lpopamp_core_0.sliceB_0.bnb lpopamp_core_0.sliceB_0.bnb avss sg13_hv_nmos ad=1.125p pd=5u as=1.125p ps=5u w=4.5u l=0.5u
X2490 lpopamp_core_0.sliceA_1.zp_m lpopamp_core_0.sliceA_1.zp_m lpopamp_core_0.sliceA_1.yp_p avdd sg13_hv_pmos ad=1.125p pd=5u as=1.125p ps=5u w=4.5u l=0.5u
X2491 a_27550_100# lpopamp_core_0.sliceA_0.zn_m zn_p avss sg13_hv_nmos ad=1.125p pd=5u as=1.125p ps=5u w=4.5u l=0.5u
X2492 lpopamp_core_0.sliceA_1.bpb lpopamp_core_0.sliceA_1.bpb lpopamp_core_0.sliceA_1.bpa_r avdd sg13_hv_pmos ad=1.125p pd=5u as=1.125p ps=5u w=4.5u l=0.5u
X2493 a_20050_100# lpopamp_core_0.sliceA_0.bnb a_20350_100# avss sg13_hv_nmos ad=1.125p pd=5u as=1.125p ps=5u w=4.5u l=0.5u
X2494 a_10950_4750# lpopamp_core_0.sliceB_0.bpa_r lpopamp_core_0.sliceB_0.bpa_r avdd sg13_hv_pmos ad=1.125p pd=5u as=1.125p ps=5u w=4.5u l=0.5u
X2495 ib en lpopamp_core_0.sliceB_0.bna avss sg13_hv_nmos ad=1.125p pd=5u as=1.125p ps=5u w=4.5u l=1.5u
X2496 a_11950_7800# lpopamp_core_0.sliceB_1.bnb lpopamp_core_0.sliceB_1.bnb avss sg13_hv_nmos ad=1.125p pd=5u as=1.125p ps=5u w=4.5u l=0.5u
X2497 out zp_p avdd avdd sg13_hv_pmos ad=1.125p pd=5u as=1.125p ps=5u w=4.5u l=0.5u
X2498 avdd lpopamp_core_0.sliceA_0.zp_m lpopamp_core_0.sliceA_0.yp_p avdd sg13_hv_pmos ad=1.125p pd=5u as=1.125p ps=5u w=4.5u l=3.5u
X2499 lpopamp_core_0.sliceB_0.xp in_m lpopamp_core_0.sliceB_0.yn_p avdd sg13_hv_pmos ad=1.125p pd=5u as=1.125p ps=5u w=4.5u l=0.5u
X2500 a_27150_7150# lpopamp_core_0.sliceB_0.zn_m zn_p avss sg13_hv_nmos ad=1.125p pd=5u as=1.125p ps=5u w=4.5u l=0.5u
X2501 lpopamp_core_0.sliceB_1.bpa_l lpopamp_core_0.sliceB_1.bpb lpopamp_core_0.sliceB_1.bpb avdd sg13_hv_pmos ad=1.125p pd=5u as=1.125p ps=5u w=4.5u l=0.5u
X2502 a_8550_14250# lpopamp_core_0.sliceA_1.bna_ a_8450_14250# avss sg13_hv_nmos ad=1.125p pd=5u as=1.125p ps=5u w=4.5u l=0.5u
X2503 lpopamp_core_0.sliceB_0.yp_p lpopamp_core_0.sliceB_0.zp_m avdd avdd sg13_hv_pmos ad=1.125p pd=5u as=1.125p ps=5u w=4.5u l=3.5u
X2504 a_10750_6550# lpopamp_core_0.sliceB_0.bnb lpopamp_core_0.sliceB_0.bnb avss sg13_hv_nmos ad=1.125p pd=5u as=1.125p ps=5u w=4.5u l=0.5u
X2505 lpopamp_core_0.sliceA_1.zp_m lpopamp_core_0.sliceA_1.zp_m lpopamp_core_0.sliceA_1.yp_p avdd sg13_hv_pmos ad=1.125p pd=5u as=1.125p ps=5u w=4.5u l=0.5u
X2506 lpopamp_core_0.sliceA_0.yp_m lpopamp_core_0.sliceA_0.zp_m zp_p avdd sg13_hv_pmos ad=1.125p pd=5u as=1.125p ps=5u w=4.5u l=0.5u
X2507 a_23850_11850# lpopamp_core_0.sliceA_1.bpb lpopamp_core_0.sliceA_1.zn_m avdd sg13_hv_pmos ad=1.125p pd=5u as=1.125p ps=5u w=4.5u l=0.5u
X2508 a_8650_100# lpopamp_core_0.sliceA_0.bna_ a_8550_100# avss sg13_hv_nmos ad=1.125p pd=5u as=1.125p ps=5u w=4.5u l=0.5u
X2509 avdd lpopamp_core_0.sliceB_1.zp_m lpopamp_core_0.sliceB_1.yp_p avdd sg13_hv_pmos ad=1.125p pd=5u as=1.125p ps=5u w=4.5u l=3.5u
X2510 a_12650_100# lpopamp_core_0.sliceA_0.bna_ a_12550_100# avss sg13_hv_nmos ad=1.125p pd=5u as=1.125p ps=5u w=4.5u l=0.5u
X2511 a_20050_100# lpopamp_core_0.sliceA_0.bna a_19650_100# avss sg13_hv_nmos ad=1.125p pd=5u as=1.125p ps=5u w=4.5u l=3.5u
X2512 avdd lpopamp_core_0.sliceA_0.bpa a_23850_2500# avdd sg13_hv_pmos ad=1.125p pd=5u as=1.125p ps=5u w=4.5u l=3.5u
X2513 lpopamp_core_0.sliceB_1.bpb lpopamp_core_0.sliceB_1.bpb lpopamp_core_0.sliceB_1.bpa_r avdd sg13_hv_pmos ad=1.125p pd=5u as=1.125p ps=5u w=4.5u l=0.5u
X2514 lpopamp_core_0.sliceA_0.bpa_l lpopamp_core_0.sliceA_0.bpb lpopamp_core_0.sliceA_0.bpb avdd sg13_hv_pmos ad=1.125p pd=5u as=1.125p ps=5u w=4.5u l=0.5u
X2515 a_15150_6550# in_m lpopamp_core_0.sliceB_0.yp_p avss sg13_hv_nmos ad=1.125p pd=5u as=1.125p ps=5u w=4.5u l=0.5u
X2516 lpopamp_core_0.sliceA_1.bnb lpopamp_core_0.sliceA_1.bnb a_11750_14850# avss sg13_hv_nmos ad=1.125p pd=5u as=1.125p ps=5u w=4.5u l=0.5u
X2517 a_26950_14850# lpopamp_core_0.sliceA_1.bnb zp_p avss sg13_hv_nmos ad=1.125p pd=5u as=1.125p ps=5u w=4.5u l=0.5u
X2518 zn_p lpopamp_core_0.sliceB_1.bpb zp_p avdd sg13_hv_pmos ad=1.125p pd=5u as=1.125p ps=5u w=4.5u l=0.5u
X2519 avss lpopamp_core_0.sliceA_0.bna a_21650_700# avss sg13_hv_nmos ad=1.125p pd=5u as=1.125p ps=5u w=4.5u l=3.5u
X2520 avss zn_p a_28750_700# avss sg13_hv_nmos ad=1.125p pd=5u as=1.125p ps=5u w=4.5u l=0.5u
X2521 lpopamp_core_0.sliceB_1.bna lpopamp_core_0.sliceB_1.bna a_2850_7800# avss sg13_hv_nmos ad=1.125p pd=5u as=1.125p ps=5u w=4.5u l=3.5u
X2522 avss lpopamp_core_0.sliceA_1.bna a_15650_14850# avss sg13_hv_nmos ad=1.125p pd=5u as=1.125p ps=5u w=4.5u l=3.5u
X2523 out zp_p a_29450_10800# avdd sg13_hv_pmos ad=1.125p pd=5u as=1.125p ps=5u w=4.5u l=0.5u
X2524 lpopamp_core_0.sliceA_0.yp_p lpopamp_core_0.sliceA_0.zp_m lpopamp_core_0.sliceA_0.zp_m avdd sg13_hv_pmos ad=1.125p pd=5u as=1.125p ps=5u w=4.5u l=0.5u
X2525 zp_p lpopamp_core_0.sliceB_0.bpb zn_p avdd sg13_hv_pmos ad=1.125p pd=5u as=1.125p ps=5u w=4.5u l=0.5u
X2526 lpopamp_core_0.sliceB_0.bpa_r lpopamp_core_0.sliceB_0.bpb lpopamp_core_0.sliceB_0.bpb avdd sg13_hv_pmos ad=1.125p pd=5u as=1.125p ps=5u w=4.5u l=0.5u
X2527 a_26750_7800# lpopamp_core_0.sliceB_1.bnb zn_p avss sg13_hv_nmos ad=1.125p pd=5u as=1.125p ps=5u w=4.5u l=0.5u
X2528 lpopamp_core_0.sliceB_1.yn_p in_m lpopamp_core_0.sliceB_1.xp avdd sg13_hv_pmos ad=1.125p pd=5u as=1.125p ps=5u w=4.5u l=0.5u
X2529 out zn_p a_28950_100# avss sg13_hv_nmos ad=1.125p pd=5u as=1.125p ps=5u w=4.5u l=0.5u
X2530 out zp_p a_29850_4150# avdd sg13_hv_pmos ad=1.125p pd=5u as=1.125p ps=5u w=4.5u l=0.5u
X2531 lpopamp_core_0.sliceB_1.zn_m lpopamp_core_0.sliceB_1.zn_m a_23350_7800# avss sg13_hv_nmos ad=1.125p pd=5u as=1.125p ps=5u w=4.5u l=0.5u
X2532 avss zn_p a_28750_6550# avss sg13_hv_nmos ad=1.125p pd=5u as=1.125p ps=5u w=4.5u l=0.5u
X2533 a_7650_7800# lpopamp_core_0.sliceB_1.bna lpopamp_core_0.sliceB_1.bpb avss sg13_hv_nmos ad=1.125p pd=5u as=1.125p ps=5u w=4.5u l=3.5u
X2534 lpopamp_core_0.sliceA_1.bpa lpopamp_core_0.sliceA_1.bpa avdd avdd sg13_hv_pmos ad=1.125p pd=5u as=1.125p ps=5u w=4.5u l=3.5u
X2535 avdd lpopamp_core_0.sliceA_0.bpa lpopamp_core_0.sliceA_0.bnb avdd sg13_hv_pmos ad=1.125p pd=5u as=1.125p ps=5u w=4.5u l=3.5u
X2536 a_20150_7800# lpopamp_core_0.sliceB_1.bnb a_20050_7800# avss sg13_hv_nmos ad=1.125p pd=5u as=1.125p ps=5u w=4.5u l=0.5u
X2537 lpopamp_core_0.sliceB_0.bnb lpopamp_core_0.sliceB_0.bnb a_9350_6550# avss sg13_hv_nmos ad=1.125p pd=5u as=1.125p ps=5u w=4.5u l=0.5u
X2538 avdd lpopamp_core_0.sliceA_1.bpa_l a_8750_11850# avdd sg13_hv_pmos ad=1.125p pd=5u as=1.125p ps=5u w=4.5u l=0.5u
X2539 a_9950_700# lpopamp_core_0.sliceA_0.bnb lpopamp_core_0.sliceA_0.bnb avss sg13_hv_nmos ad=1.125p pd=5u as=1.125p ps=5u w=4.5u l=0.5u
X2540 lpopamp_core_0.sliceB_0.bpa_l lpopamp_core_0.sliceB_0.bpb lpopamp_core_0.sliceB_0.bpb avdd sg13_hv_pmos ad=1.125p pd=5u as=1.125p ps=5u w=4.5u l=0.5u
X2541 a_13950_700# in_m lpopamp_core_0.sliceA_0.yp_p avss sg13_hv_nmos ad=1.125p pd=5u as=1.125p ps=5u w=4.5u l=0.5u
X2542 avss lpopamp_core_0.sliceB_0.bna a_6050_6550# avss sg13_hv_nmos ad=1.125p pd=5u as=1.125p ps=5u w=4.5u l=3.5u
X2543 lpopamp_core_0.sliceB_1.bpb lpopamp_core_0.sliceB_1.bpb lpopamp_core_0.sliceB_1.bpa_r avdd sg13_hv_pmos ad=1.125p pd=5u as=1.125p ps=5u w=4.5u l=0.5u
X2544 avss zn_p a_29950_14250# avss sg13_hv_nmos ad=1.125p pd=5u as=1.125p ps=5u w=4.5u l=0.5u
X2545 lpopamp_core_0.sliceB_0.yp_p lpopamp_core_0.sliceB_0.zp_m lpopamp_core_0.sliceB_0.zp_m avdd sg13_hv_pmos ad=1.125p pd=5u as=1.125p ps=5u w=4.5u l=0.5u
X2546 a_14150_100# in_m lpopamp_core_0.sliceA_0.xn avss sg13_hv_nmos ad=1.125p pd=5u as=1.125p ps=5u w=4.5u l=0.5u
X2547 lpopamp_core_0.sliceB_1.zn_m lpopamp_core_0.sliceB_1.bpb a_22450_10200# avdd sg13_hv_pmos ad=1.125p pd=5u as=1.125p ps=5u w=4.5u l=0.5u
X2548 a_13950_8400# in_p lpopamp_core_0.sliceB_1.yp_m avss sg13_hv_nmos ad=1.125p pd=5u as=1.125p ps=5u w=4.5u l=0.5u
X2549 lpopamp_core_0.sliceA_1.zn_m lpopamp_core_0.sliceA_1.zn_m a_23750_14250# avss sg13_hv_nmos ad=1.125p pd=5u as=1.125p ps=5u w=4.5u l=0.5u
X2550 lpopamp_core_0.sliceB_1.bnb lpopamp_core_0.sliceB_1.bpa avdd avdd sg13_hv_pmos ad=1.125p pd=5u as=1.125p ps=5u w=4.5u l=3.5u
X2551 lpopamp_core_0.sliceA_0.yn_p lpopamp_core_0.sliceA_0.zn_m a_23150_700# avss sg13_hv_nmos ad=1.125p pd=5u as=1.125p ps=5u w=4.5u l=0.5u
X2552 a_22950_100# lpopamp_core_0.sliceA_0.zn_m lpopamp_core_0.sliceA_0.yn_p avss sg13_hv_nmos ad=1.125p pd=5u as=1.125p ps=5u w=4.5u l=0.5u
X2553 a_12650_14250# lpopamp_core_0.sliceA_1.bna_ a_12550_14250# avss sg13_hv_nmos ad=1.125p pd=5u as=1.125p ps=5u w=4.5u l=0.5u
X2554 lpopamp_core_0.sliceA_0.zn_m lpopamp_core_0.sliceA_0.bpb a_22450_2500# avdd sg13_hv_pmos ad=1.125p pd=5u as=1.125p ps=5u w=4.5u l=0.5u
X2555 lpopamp_core_0.sliceA_0.bpa_l lpopamp_core_0.sliceA_0.bpa_l a_6750_2500# avdd sg13_hv_pmos ad=1.125p pd=5u as=1.125p ps=5u w=4.5u l=0.5u
X2556 a_28050_14250# lpopamp_core_0.sliceA_1.zn_m lpopamp_core_0.sliceA_1.yn_m avss sg13_hv_nmos ad=1.125p pd=5u as=1.125p ps=5u w=4.5u l=3.5u
X2557 lpopamp_core_0.sliceB_1.bnb lpopamp_core_0.sliceB_1.bnb a_10550_8400# avss sg13_hv_nmos ad=1.125p pd=5u as=1.125p ps=5u w=4.5u l=0.5u
X2558 lpopamp_core_0.sliceA_1.yn_p lpopamp_core_0.sliceA_1.zn_m a_16450_14250# avss sg13_hv_nmos ad=1.125p pd=5u as=1.125p ps=5u w=4.5u l=3.5u
X2559 avdd lpopamp_core_0.sliceA_0.tihi lpopamp_core_0.sliceA_0.tihi avdd sg13_hv_pmos ad=1.125p pd=5u as=1.125p ps=5u w=4.5u l=9.5u
X2560 a_12750_7150# lpopamp_core_0.sliceB_0.bna_ a_12650_7150# avss sg13_hv_nmos ad=1.125p pd=5u as=1.125p ps=5u w=4.5u l=0.5u
X2561 avdd lpopamp_core_0.sliceA_1.zp_m lpopamp_core_0.sliceA_1.yp_p avdd sg13_hv_pmos ad=1.125p pd=5u as=1.125p ps=5u w=4.5u l=3.5u
X2562 zp_p lpopamp_core_0.sliceA_0.zp_m lpopamp_core_0.sliceA_0.yp_m avdd sg13_hv_pmos ad=1.125p pd=5u as=1.125p ps=5u w=4.5u l=0.5u
X2563 lpopamp_core_0.sliceB_1.yp_p in_m a_14950_8400# avss sg13_hv_nmos ad=1.125p pd=5u as=1.125p ps=5u w=4.5u l=0.5u
X2564 a_23850_11850# lpopamp_core_0.sliceA_1.bpb lpopamp_core_0.sliceA_1.zn_m avdd sg13_hv_pmos ad=1.125p pd=5u as=1.125p ps=5u w=4.5u l=0.5u
X2565 a_23850_2500# lpopamp_core_0.sliceA_0.bpb lpopamp_core_0.sliceA_0.zn_m avdd sg13_hv_pmos ad=1.125p pd=5u as=1.125p ps=5u w=4.5u l=0.5u
X2566 avdd lpopamp_core_0.sliceA_1.zp_m lpopamp_core_0.sliceA_1.yp_m avdd sg13_hv_pmos ad=1.125p pd=5u as=1.125p ps=5u w=4.5u l=3.5u
X2567 avdd en lpopamp_core_0.sliceB_1.enb avdd sg13_hv_pmos ad=1.125p pd=5u as=1.125p ps=5u w=4.5u l=1.5u
X2568 a_5250_8400# lpopamp_core_0.sliceB_1.bna avss avss sg13_hv_nmos ad=1.125p pd=5u as=1.125p ps=5u w=4.5u l=3.5u
X2569 a_28750_8400# zn_p out avss sg13_hv_nmos ad=1.125p pd=5u as=1.125p ps=5u w=4.5u l=0.5u
X2570 avdd en zp_p avdd sg13_hv_pmos ad=2.25p pd=10u as=1.125p ps=5u w=4.5u l=1.5u
X2571 a_9350_8400# lpopamp_core_0.sliceB_1.bnb lpopamp_core_0.sliceB_1.bna_ avss sg13_hv_nmos ad=1.125p pd=5u as=1.125p ps=5u w=4.5u l=0.5u
X2572 a_22450_11850# lpopamp_core_0.sliceA_1.bpb lpopamp_core_0.sliceA_1.zn_m avdd sg13_hv_pmos ad=1.125p pd=5u as=1.125p ps=5u w=4.5u l=0.5u
X2573 lpopamp_core_0.sliceA_1.yp_p lpopamp_core_0.sliceA_1.zp_m avdd avdd sg13_hv_pmos ad=1.125p pd=5u as=1.125p ps=5u w=4.5u l=3.5u
X2574 lpopamp_core_0.sliceB_1.yp_p lpopamp_core_0.sliceB_1.zp_m avdd avdd sg13_hv_pmos ad=1.125p pd=5u as=1.125p ps=5u w=4.5u l=3.5u
X2575 a_4050_7150# lpopamp_core_0.sliceB_0.bna lpopamp_core_0.sliceB_0.bna avss sg13_hv_nmos ad=1.125p pd=5u as=1.125p ps=5u w=4.5u l=3.5u
X2576 lpopamp_core_0.sliceA_0.yp_m lpopamp_core_0.sliceA_0.zp_m avdd avdd sg13_hv_pmos ad=1.125p pd=5u as=1.125p ps=5u w=4.5u l=3.5u
X2577 lpopamp_core_0.sliceA_1.bna_ lpopamp_core_0.sliceA_1.bnb a_10750_14850# avss sg13_hv_nmos ad=1.125p pd=5u as=1.125p ps=5u w=4.5u l=0.5u
X2578 lpopamp_core_0.sliceA_1.xp in_m lpopamp_core_0.sliceA_1.yn_p avdd sg13_hv_pmos ad=1.125p pd=5u as=1.125p ps=5u w=4.5u l=0.5u
X2579 a_22450_8400# lpopamp_core_0.sliceB_1.zn_m avss avss sg13_hv_nmos ad=1.125p pd=5u as=1.125p ps=5u w=4.5u l=3.5u
X2580 a_27550_7150# lpopamp_core_0.sliceB_0.zn_m zn_p avss sg13_hv_nmos ad=1.125p pd=5u as=1.125p ps=5u w=4.5u l=0.5u
X2581 a_25950_14850# lpopamp_core_0.sliceA_1.zn_m zn_p avss sg13_hv_nmos ad=1.125p pd=5u as=1.125p ps=5u w=4.5u l=0.5u
X2582 a_14750_14850# in_p lpopamp_core_0.sliceA_1.yp_m avss sg13_hv_nmos ad=1.125p pd=5u as=1.125p ps=5u w=4.5u l=0.5u
X2583 out zp_p avdd avdd sg13_hv_pmos ad=1.125p pd=5u as=1.125p ps=5u w=4.5u l=0.5u
X2584 avdd lpopamp_core_0.sliceA_0.bpa_r a_11150_3100# avdd sg13_hv_pmos ad=1.125p pd=5u as=1.125p ps=5u w=4.5u l=0.5u
X2585 avdd lpopamp_core_0.sliceB_0.zp_m lpopamp_core_0.sliceB_0.yp_p avdd sg13_hv_pmos ad=1.125p pd=5u as=1.125p ps=5u w=4.5u l=3.5u
X2586 out zn_p a_29750_14850# avss sg13_hv_nmos ad=1.125p pd=5u as=1.125p ps=5u w=4.5u l=0.5u
X2587 a_8150_7150# lpopamp_core_0.sliceB_0.bna_ avss avss sg13_hv_nmos ad=1.125p pd=5u as=1.125p ps=5u w=4.5u l=0.5u
X2588 avdd lpopamp_core_0.sliceB_1.bpa lpopamp_core_0.sliceB_1.xp avdd sg13_hv_pmos ad=1.125p pd=5u as=1.125p ps=5u w=4.5u l=3.5u
X2589 lpopamp_core_0.sliceB_0.zp_m lpopamp_core_0.sliceB_0.zp_m lpopamp_core_0.sliceB_0.yp_p avdd sg13_hv_pmos ad=1.125p pd=5u as=1.125p ps=5u w=4.5u l=0.5u
X2590 lpopamp_core_0.sliceB_0.xp in_p lpopamp_core_0.sliceB_0.yn_m avdd sg13_hv_pmos ad=1.125p pd=5u as=1.125p ps=5u w=4.5u l=0.5u
X2591 lpopamp_core_0.sliceA_0.yp_m lpopamp_core_0.sliceA_0.zp_m avdd avdd sg13_hv_pmos ad=1.125p pd=5u as=1.125p ps=5u w=4.5u l=3.5u
X2592 avdd lpopamp_core_0.sliceA_0.bpa_l a_8750_3100# avdd sg13_hv_pmos ad=1.125p pd=5u as=1.125p ps=5u w=4.5u l=0.5u
X2593 a_10150_7800# lpopamp_core_0.sliceB_1.bnb lpopamp_core_0.sliceB_1.bna_ avss sg13_hv_nmos ad=1.125p pd=5u as=1.125p ps=5u w=4.5u l=0.5u
X2594 lpopamp_core_0.sliceA_1.bpa_l lpopamp_core_0.sliceA_1.bpb lpopamp_core_0.sliceA_1.bpb avdd sg13_hv_pmos ad=1.125p pd=5u as=1.125p ps=5u w=4.5u l=0.5u
X2595 a_25750_700# lpopamp_core_0.sliceA_0.zn_m lpopamp_core_0.sliceA_0.yn_m avss sg13_hv_nmos ad=1.125p pd=5u as=1.125p ps=5u w=4.5u l=0.5u
X2596 avdd lpopamp_core_0.sliceB_0.zp_m lpopamp_core_0.sliceB_0.yp_m avdd sg13_hv_pmos ad=1.125p pd=5u as=1.125p ps=5u w=4.5u l=3.5u
X2597 a_6050_14850# lpopamp_core_0.sliceA_1.bna lpopamp_core_0.sliceA_1.bpa avss sg13_hv_nmos ad=1.125p pd=5u as=1.125p ps=5u w=4.5u l=3.5u
X2598 lpopamp_core_0.sliceA_0.yp_p lpopamp_core_0.sliceA_0.zp_m lpopamp_core_0.sliceA_0.zp_m avdd sg13_hv_pmos ad=1.125p pd=5u as=1.125p ps=5u w=4.5u l=0.5u
X2599 a_12250_6550# lpopamp_core_0.sliceB_0.bna_ a_12150_6550# avss sg13_hv_nmos ad=1.125p pd=5u as=1.125p ps=5u w=4.5u l=0.5u
X2600 lpopamp_core_0.sliceB_1.bpb lpopamp_core_0.sliceB_1.bpb lpopamp_core_0.sliceB_1.bpa_l avdd sg13_hv_pmos ad=1.125p pd=5u as=1.125p ps=5u w=4.5u l=0.5u
X2601 out zp_p avdd avdd sg13_hv_pmos ad=1.125p pd=5u as=1.125p ps=5u w=4.5u l=0.5u
X2602 lpopamp_core_0.sliceA_1.bna_ lpopamp_core_0.sliceA_1.bnb a_9550_14850# avss sg13_hv_nmos ad=1.125p pd=5u as=1.125p ps=5u w=4.5u l=0.5u
X2603 lpopamp_core_0.sliceB_0.bpa_r lpopamp_core_0.sliceB_0.bpb lpopamp_core_0.sliceB_0.bpb avdd sg13_hv_pmos ad=1.125p pd=5u as=1.125p ps=5u w=4.5u l=0.5u
X2604 a_22450_4150# lpopamp_core_0.sliceB_0.bpb lpopamp_core_0.sliceB_0.zn_m avdd sg13_hv_pmos ad=1.125p pd=5u as=1.125p ps=5u w=4.5u l=0.5u
X2605 a_6750_4750# lpopamp_core_0.sliceB_0.bpa_l a_6650_4750# avdd sg13_hv_pmos ad=1.125p pd=5u as=1.125p ps=5u w=4.5u l=0.5u
X2606 lpopamp_core_0.sliceB_1.zn_m lpopamp_core_0.sliceB_1.zn_m a_23750_7800# avss sg13_hv_nmos ad=1.125p pd=5u as=1.125p ps=5u w=4.5u l=0.5u
X2607 avss lpopamp_core_0.sliceB_1.bna a_7650_7800# avss sg13_hv_nmos ad=1.125p pd=5u as=1.125p ps=5u w=4.5u l=3.5u
X2608 lpopamp_core_0.sliceB_1.zp_m lpopamp_core_0.sliceB_1.zp_m lpopamp_core_0.sliceB_1.yp_p avdd sg13_hv_pmos ad=1.125p pd=5u as=1.125p ps=5u w=4.5u l=0.5u
X2609 lpopamp_core_0.sliceA_0.yp_m lpopamp_core_0.sliceA_0.zp_m zp_p avdd sg13_hv_pmos ad=1.125p pd=5u as=1.125p ps=5u w=4.5u l=0.5u
X2610 lpopamp_core_0.sliceB_1.bpb lpopamp_core_0.sliceB_1.bpb lpopamp_core_0.sliceB_1.bpa_r avdd sg13_hv_pmos ad=1.125p pd=5u as=1.125p ps=5u w=4.5u l=0.5u
X2611 lpopamp_core_0.sliceA_0.yp_p lpopamp_core_0.sliceA_0.zp_m avdd avdd sg13_hv_pmos ad=1.125p pd=5u as=1.125p ps=5u w=4.5u l=3.5u
X2612 lpopamp_core_0.sliceA_1.bna_ lpopamp_core_0.sliceA_1.bnb a_11550_14250# avss sg13_hv_nmos ad=1.125p pd=5u as=1.125p ps=5u w=4.5u l=0.5u
X2613 lpopamp_core_0.sliceB_1.yp_m lpopamp_core_0.sliceB_1.zp_m zp_p avdd sg13_hv_pmos ad=1.125p pd=5u as=1.125p ps=5u w=4.5u l=0.5u
X2614 a_25950_6550# lpopamp_core_0.sliceB_0.zn_m zn_p avss sg13_hv_nmos ad=1.125p pd=5u as=1.125p ps=5u w=4.5u l=0.5u
X2615 a_20550_7800# lpopamp_core_0.sliceB_1.bnb a_20050_7800# avss sg13_hv_nmos ad=1.125p pd=5u as=1.125p ps=5u w=4.5u l=0.5u
X2616 a_26750_14250# lpopamp_core_0.sliceA_1.bnb zn_p avss sg13_hv_nmos ad=1.125p pd=5u as=1.125p ps=5u w=4.5u l=0.5u
X2617 lpopamp_core_0.sliceB_0.bnb lpopamp_core_0.sliceB_0.bnb a_9750_6550# avss sg13_hv_nmos ad=1.125p pd=5u as=1.125p ps=5u w=4.5u l=0.5u
X2618 out zp_p avdd avdd sg13_hv_pmos ad=1.125p pd=5u as=1.125p ps=5u w=4.5u l=0.5u
X2619 lpopamp_core_0.sliceB_0.yp_m lpopamp_core_0.sliceB_0.zp_m zp_p avdd sg13_hv_pmos ad=1.125p pd=5u as=1.125p ps=5u w=4.5u l=0.5u
X2620 lpopamp_core_0.sliceA_0.bna_ lpopamp_core_0.sliceA_0.bnb a_10750_700# avss sg13_hv_nmos ad=1.125p pd=5u as=1.125p ps=5u w=4.5u l=0.5u
X2621 lpopamp_core_0.sliceB_0.bpa_l lpopamp_core_0.sliceB_0.bpb lpopamp_core_0.sliceB_0.bpb avdd sg13_hv_pmos ad=1.125p pd=5u as=1.125p ps=5u w=4.5u l=0.5u
X2622 lpopamp_core_0.sliceB_1.yn_p in_m lpopamp_core_0.sliceB_1.xp avdd sg13_hv_pmos ad=1.125p pd=5u as=1.125p ps=5u w=4.5u l=0.5u
X2623 a_6850_6550# lpopamp_core_0.sliceB_0.bna avss avss sg13_hv_nmos ad=1.125p pd=5u as=1.125p ps=5u w=4.5u l=3.5u
X2624 avdd lpopamp_core_0.sliceA_0.bpa lpopamp_core_0.sliceA_0.xp avdd sg13_hv_pmos ad=1.125p pd=5u as=1.125p ps=5u w=4.5u l=3.5u
X2625 lpopamp_core_0.sliceA_0.bnb lpopamp_core_0.sliceA_0.bnb a_10950_100# avss sg13_hv_nmos ad=1.125p pd=5u as=1.125p ps=5u w=4.5u l=0.5u
X2626 lpopamp_core_0.sliceA_0.yn_m lpopamp_core_0.sliceA_0.zn_m a_18050_100# avss sg13_hv_nmos ad=1.125p pd=5u as=1.125p ps=5u w=4.5u l=3.5u
X2627 avdd lpopamp_core_0.sliceB_0.zp_m lpopamp_core_0.sliceB_0.yp_m avdd sg13_hv_pmos ad=1.125p pd=5u as=1.125p ps=5u w=4.5u l=3.5u
X2628 lpopamp_core_0.sliceA_0.yn_m lpopamp_core_0.sliceA_0.zn_m a_27150_700# avss sg13_hv_nmos ad=1.125p pd=5u as=1.125p ps=5u w=4.5u l=0.5u
X2629 a_26950_100# lpopamp_core_0.sliceA_0.bnb zp_p avss sg13_hv_nmos ad=1.125p pd=5u as=1.125p ps=5u w=4.5u l=0.5u
X2630 zp_p lpopamp_core_0.sliceA_1.zp_m lpopamp_core_0.sliceA_1.yp_m avdd sg13_hv_pmos ad=1.125p pd=5u as=1.125p ps=5u w=4.5u l=0.5u
X2631 a_20150_700# lpopamp_core_0.sliceA_0.bnb a_20050_100# avss sg13_hv_nmos ad=1.125p pd=5u as=1.125p ps=5u w=4.5u l=0.5u
X2632 zn_p lpopamp_core_0.sliceB_0.bnb a_26950_6550# avss sg13_hv_nmos ad=1.125p pd=5u as=1.125p ps=5u w=4.5u l=0.5u
X2633 a_6850_14250# lpopamp_core_0.sliceA_1.bna avss avss sg13_hv_nmos ad=1.125p pd=5u as=1.125p ps=5u w=4.5u l=3.5u
X2634 a_9150_10200# lpopamp_core_0.sliceB_1.bpa_r a_9050_10200# avdd sg13_hv_pmos ad=1.125p pd=5u as=1.125p ps=5u w=4.5u l=0.5u
X2635 zp_p lpopamp_core_0.sliceA_0.bpb zn_p avdd sg13_hv_pmos ad=1.125p pd=5u as=1.125p ps=5u w=4.5u l=0.5u
X2636 a_23850_2500# lpopamp_core_0.sliceA_0.bpb lpopamp_core_0.sliceA_0.zn_m avdd sg13_hv_pmos ad=1.125p pd=5u as=1.125p ps=5u w=4.5u l=0.5u
X2637 a_12150_8400# lpopamp_core_0.sliceB_1.bna_ lpopamp_core_0.sliceB_1.bna_ avss sg13_hv_nmos ad=1.125p pd=5u as=1.125p ps=5u w=4.5u l=0.5u
X2638 a_8350_700# lpopamp_core_0.sliceA_0.bna_ a_8250_700# avss sg13_hv_nmos ad=1.125p pd=5u as=1.125p ps=5u w=4.5u l=0.5u
X2639 lpopamp_core_0.sliceA_0.bpb lpopamp_core_0.sliceA_0.bpb lpopamp_core_0.sliceA_0.bpa_l avdd sg13_hv_pmos ad=1.125p pd=5u as=1.125p ps=5u w=4.5u l=0.5u
X2640 a_25250_14850# lpopamp_core_0.sliceA_1.zn_m avss avss sg13_hv_nmos ad=1.125p pd=5u as=1.125p ps=5u w=4.5u l=3.5u
X2641 a_12350_700# lpopamp_core_0.sliceA_0.bna_ a_12250_700# avss sg13_hv_nmos ad=1.125p pd=5u as=1.125p ps=5u w=4.5u l=0.5u
X2642 lpopamp_core_0.sliceA_0.zp_m lpopamp_core_0.sliceA_0.zp_m lpopamp_core_0.sliceA_0.yp_p avdd sg13_hv_pmos ad=1.125p pd=5u as=1.125p ps=5u w=4.5u l=0.5u
X2643 a_13750_14850# in_m lpopamp_core_0.sliceA_1.xn avss sg13_hv_nmos ad=1.125p pd=5u as=1.125p ps=5u w=4.5u l=0.5u
X2644 lpopamp_core_0.sliceA_1.zp_m lpopamp_core_0.sliceA_1.zp_m lpopamp_core_0.sliceA_1.yp_p avdd sg13_hv_pmos ad=1.125p pd=5u as=1.125p ps=5u w=4.5u l=0.5u
X2645 zp_p lpopamp_core_0.sliceB_1.bpb zn_p avdd sg13_hv_pmos ad=1.125p pd=5u as=1.125p ps=5u w=4.5u l=0.5u
X2646 avss zn_p a_28750_14850# avss sg13_hv_nmos ad=1.125p pd=5u as=1.125p ps=5u w=4.5u l=0.5u
X2647 lpopamp_core_0.sliceB_0.yp_m in_p a_14150_7150# avss sg13_hv_nmos ad=1.125p pd=5u as=1.125p ps=5u w=4.5u l=0.5u
X2648 zn_p lpopamp_core_0.sliceB_1.zn_m a_25750_8400# avss sg13_hv_nmos ad=1.125p pd=5u as=1.125p ps=5u w=4.5u l=0.5u
X2649 a_9750_8400# lpopamp_core_0.sliceB_1.bnb lpopamp_core_0.sliceB_1.bna_ avss sg13_hv_nmos ad=1.125p pd=5u as=1.125p ps=5u w=4.5u l=0.5u
X2650 a_21650_100# lpopamp_core_0.sliceA_0.bna a_20050_100# avss sg13_hv_nmos ad=1.125p pd=5u as=1.125p ps=5u w=4.5u l=3.5u
X2651 lpopamp_core_0.sliceB_1.yn_p lpopamp_core_0.sliceB_1.zn_m a_22450_8400# avss sg13_hv_nmos ad=1.125p pd=5u as=1.125p ps=5u w=4.5u l=3.5u
X2652 avdd lpopamp_core_0.sliceA_0.zp_m lpopamp_core_0.sliceA_0.yp_m avdd sg13_hv_pmos ad=1.125p pd=5u as=1.125p ps=5u w=4.5u l=3.5u
X2653 lpopamp_core_0.sliceA_1.bpa_l lpopamp_core_0.sliceA_1.bpa_l a_6750_11850# avdd sg13_hv_pmos ad=1.125p pd=5u as=1.125p ps=5u w=4.5u l=0.5u
X2654 avss lpopamp_core_0.sliceA_1.enb lpopamp_core_0.sliceA_1.bna avss sg13_hv_nmos ad=1.125p pd=5u as=1.125p ps=5u w=4.5u l=1.5u
X2655 a_8550_7150# lpopamp_core_0.sliceB_0.bna_ a_8450_7150# avss sg13_hv_nmos ad=1.125p pd=5u as=1.125p ps=5u w=4.5u l=0.5u
C0 lpopamp_core_0.sliceB_1.yn_p in_m 5.48943f
C1 lpopamp_core_0.sliceA_1.bpa a_23850_11850# 1.61069f
C2 lpopamp_core_0.sliceB_0.yp_p lpopamp_core_0.sliceB_0.zp_m 24.3518f
C3 lpopamp_core_0.sliceA_0.bnb lpopamp_core_0.sliceA_0.bna 7.13374f
C4 lpopamp_core_0.sliceB_1.zp_m avdd 0.11866p
C5 lpopamp_core_0.sliceA_0.yp_p in_m 2.7765f
C6 lpopamp_core_0.sliceB_0.bnb avdd 3.1046f
C7 lpopamp_core_0.sliceB_1.bpa lpopamp_core_0.sliceB_1.zp_m 1.63057f
C8 lpopamp_core_0.sliceA_0.bpa avdd 0.11862p
C9 a_22450_10200# avdd 2.02726f
C10 lpopamp_core_0.sliceB_0.yp_m in_p 4.19047f
C11 avdd in_m 26.7727f
C12 lpopamp_core_0.sliceA_1.zn_m lpopamp_core_0.sliceA_1.bpb 4.69389f
C13 lpopamp_core_0.sliceA_1.zp_m avdd 0.11909p
C14 lpopamp_core_0.sliceA_1.zn_m lpopamp_core_0.sliceA_1.yn_m 11.2462f
C15 lpopamp_core_0.sliceB_1.bpa a_22450_10200# 1.61108f
C16 lpopamp_core_0.sliceB_1.zp_m lpopamp_core_0.sliceB_1.yp_p 24.3518f
C17 lpopamp_core_0.sliceA_0.yp_m avdd 18.1177f
C18 lpopamp_core_0.sliceB_1.zn_m out 3.58001f
C19 lpopamp_core_0.sliceB_1.xp lpopamp_core_0.sliceB_1.yn_p 3.56806f
C20 lpopamp_core_0.sliceA_0.enb lpopamp_core_0.sliceA_0.zn_m 1.21778f
C21 lpopamp_core_0.sliceB_1.yp_p in_m 2.7765f
C22 lpopamp_core_0.sliceB_1.bpa_l avdd 11.6445f
C23 lpopamp_core_0.sliceA_1.bpb a_23850_11850# 2.25051f
C24 lpopamp_core_0.sliceB_1.bpa lpopamp_core_0.sliceB_1.bna 1.58919f
C25 lpopamp_core_0.sliceB_1.xp avdd 5.13125f
C26 avdd en 0.24914p
C27 lpopamp_core_0.sliceA_1.bpb lpopamp_core_0.sliceA_1.bpa_r 12.0076f
C28 zp_p out 4.81178p
C29 lpopamp_core_0.sliceB_1.bpa lpopamp_core_0.sliceB_1.xp 4.53548f
C30 lpopamp_core_0.sliceB_1.bpa en 2.43842f
C31 lpopamp_core_0.sliceA_1.zn_m zn_p 3.47337f
C32 lpopamp_core_0.sliceA_0.bpb lpopamp_core_0.sliceA_0.zn_m 4.69389f
C33 lpopamp_core_0.sliceA_0.yn_p lpopamp_core_0.sliceA_0.zn_m 13.5782f
C34 lpopamp_core_0.sliceB_1.bnb avdd 3.1046f
C35 in_p out 11.0826f
C36 lpopamp_core_0.sliceA_1.bpa a_22450_11850# 1.61108f
C37 lpopamp_core_0.sliceA_0.yn_m out 2.26168f
C38 lpopamp_core_0.sliceB_1.bpa lpopamp_core_0.sliceB_1.bnb 3.32557f
C39 lpopamp_core_0.sliceB_0.zp_m avdd 0.11866p
C40 lpopamp_core_0.sliceA_1.bpa avdd 0.11862p
C41 lpopamp_core_0.sliceA_1.yn_p avdd 2.13191f
C42 lpopamp_core_0.sliceB_1.zp_m out 1.94781f
C43 zn_p lpopamp_core_0.sliceA_0.enb 1.99594f
C44 lpopamp_core_0.sliceB_0.bpb lpopamp_core_0.sliceB_0.bpa_l 11.917f
C45 in_m out 5.53531f
C46 lpopamp_core_0.sliceA_0.zn_m avdd 3.68638f
C47 lpopamp_core_0.sliceA_1.zp_m out 1.94796f
C48 zp_p in_p 4.96117f
C49 a_22450_10200# lpopamp_core_0.sliceB_1.zn_m 2.88641f
C50 lpopamp_core_0.sliceA_1.bpb a_22450_11850# 2.25051f
C51 lpopamp_core_0.sliceB_0.yp_m lpopamp_core_0.sliceB_0.zp_m 17.6411f
C52 zn_p lpopamp_core_0.sliceA_0.bpb 2.98212f
C53 lpopamp_core_0.sliceB_0.bpa lpopamp_core_0.sliceB_0.xp 4.53548f
C54 lpopamp_core_0.sliceA_0.enb lpopamp_core_0.sliceA_0.bna 2.95512f
C55 a_23850_10200# avdd 2.02756f
C56 lpopamp_core_0.sliceB_0.yn_m lpopamp_core_0.sliceB_0.xp 3.56806f
C57 lpopamp_core_0.sliceA_0.bpb lpopamp_core_0.sliceA_0.zp_m 1.50171f
C58 zp_p lpopamp_core_0.sliceB_1.zp_m 5.40181f
C59 lpopamp_core_0.sliceA_1.bpb avdd 74.6438f
C60 lpopamp_core_0.sliceA_1.yn_m avdd 2.13191f
C61 zp_p lpopamp_core_0.sliceB_0.bnb 2.21812f
C62 en out 4.81883f
C63 lpopamp_core_0.sliceB_1.bpa a_23850_10200# 1.61069f
C64 lpopamp_core_0.sliceA_0.bpb a_22450_2500# 2.25051f
C65 zp_p in_m 1.51163f
C66 lpopamp_core_0.sliceA_0.yn_m in_p 4.02283f
C67 lpopamp_core_0.sliceA_1.zp_m zp_p 5.40188f
C68 lpopamp_core_0.sliceA_1.zn_m lpopamp_core_0.sliceA_1.bnb 1.3099f
C69 zp_p lpopamp_core_0.sliceA_0.yp_m 6.56825f
C70 lpopamp_core_0.sliceB_0.tihi avdd 27.3348f
C71 lpopamp_core_0.sliceB_1.xn in_p 2.45776f
C72 lpopamp_core_0.sliceA_0.bpb lpopamp_core_0.sliceA_0.bna 1.58919f
C73 lpopamp_core_0.sliceA_0.bpa_l lpopamp_core_0.sliceA_0.bpb 11.917f
C74 lpopamp_core_0.sliceB_0.bpa avdd 0.11889p
C75 en ib 6.82222f
C76 in_m in_p 2.30058f
C77 lpopamp_core_0.sliceB_0.yn_m avdd 2.27039f
C78 lpopamp_core_0.sliceA_0.enb lpopamp_core_0.sliceA_0.bnb 8.31444f
C79 lpopamp_core_0.sliceA_0.zp_m lpopamp_core_0.sliceA_0.yp_p 25.4502f
C80 lpopamp_core_0.sliceB_0.yn_p lpopamp_core_0.sliceB_0.xp 3.56806f
C81 lpopamp_core_0.sliceA_1.bpa_l avdd 11.6566f
C82 zp_p en 8.8824f
C83 lpopamp_core_0.sliceA_0.yp_m in_p 4.21111f
C84 zn_p avdd 12.0255f
C85 lpopamp_core_0.sliceB_1.bnb lpopamp_core_0.sliceB_1.zn_m 1.3099f
C86 lpopamp_core_0.sliceA_0.xp lpopamp_core_0.sliceA_0.yn_p 3.56806f
C87 lpopamp_core_0.sliceA_0.zp_m avdd 0.11909p
C88 lpopamp_core_0.sliceB_0.zp_m out 1.94781f
C89 lpopamp_core_0.sliceB_1.xn in_m 2.46021f
C90 a_22450_2500# avdd 1.96416f
C91 lpopamp_core_0.sliceA_1.yn_p out 1.96732f
C92 lpopamp_core_0.sliceB_1.xp in_p 2.8357f
C93 lpopamp_core_0.sliceB_0.bpa lpopamp_core_0.sliceB_0.yp_m 1.31028f
C94 lpopamp_core_0.sliceA_0.zn_m out 3.58001f
C95 lpopamp_core_0.sliceB_1.bna lpopamp_core_0.sliceB_1.xn 1.80641f
C96 lpopamp_core_0.sliceA_0.bnb lpopamp_core_0.sliceA_0.bna_ 10.5436f
C97 lpopamp_core_0.sliceA_0.bpa lpopamp_core_0.sliceA_0.yp_m 1.45942f
C98 zp_p lpopamp_core_0.sliceB_1.bnb 2.21812f
C99 lpopamp_core_0.sliceB_1.enb avdd 1.02038f
C100 lpopamp_core_0.sliceB_0.bpb avdd 75.3579f
C101 lpopamp_core_0.sliceB_0.zn_m avdd 3.9184f
C102 lpopamp_core_0.sliceA_1.enb en 5.87088f
C103 lpopamp_core_0.sliceB_0.yn_p avdd 2.27039f
C104 lpopamp_core_0.sliceB_1.bpb lpopamp_core_0.sliceB_1.bpa_r 12.0076f
C105 lpopamp_core_0.sliceA_0.bpa_l avdd 11.6566f
C106 zp_p lpopamp_core_0.sliceB_0.zp_m 5.40181f
C107 lpopamp_core_0.sliceB_0.bna lpopamp_core_0.sliceB_0.bnb 7.13374f
C108 lpopamp_core_0.sliceA_0.xp avdd 5.0145f
C109 lpopamp_core_0.sliceA_1.yn_m out 2.26168f
C110 lpopamp_core_0.sliceA_0.bpa en 2.43842f
C111 lpopamp_core_0.sliceB_1.xp in_m 2.8345f
C112 lpopamp_core_0.sliceA_0.zp_m a_20050_100# 1.38781f
C113 lpopamp_core_0.sliceA_1.enb lpopamp_core_0.sliceA_1.bna 2.95512f
C114 lpopamp_core_0.sliceB_1.bpb avdd 75.3579f
C115 lpopamp_core_0.sliceB_1.zn_m a_23850_10200# 2.88641f
C116 lpopamp_core_0.sliceB_0.enb avdd 1.02038f
C117 lpopamp_core_0.sliceB_1.bpa lpopamp_core_0.sliceB_1.bpb 9.77074f
C118 lpopamp_core_0.sliceB_1.yn_m avdd 2.27039f
C119 lpopamp_core_0.sliceA_1.xp avdd 5.0145f
C120 lpopamp_core_0.sliceA_1.zn_m a_23850_11850# 2.88641f
C121 lpopamp_core_0.sliceB_0.bpa a_23850_4150# 1.61069f
C122 lpopamp_core_0.sliceB_1.zp_m lpopamp_core_0.sliceB_1.bnb 2.8492f
C123 lpopamp_core_0.sliceA_0.bnb avdd 2.98756f
C124 lpopamp_core_0.sliceB_1.bna en 1.86149f
C125 lpopamp_core_0.sliceB_0.bna en 1.86149f
C126 lpopamp_core_0.sliceA_0.bpb a_23850_2500# 2.25051f
C127 lpopamp_core_0.sliceB_0.yn_m out 2.26168f
C128 lpopamp_core_0.sliceA_1.bpb zp_p 3.30671f
C129 lpopamp_core_0.sliceA_0.bna a_20050_100# 1.84008f
C130 lpopamp_core_0.sliceA_1.bnb avdd 2.98756f
C131 lpopamp_core_0.sliceB_1.tihi avdd 27.3348f
C132 zn_p out 4.80402p
C133 lpopamp_core_0.sliceA_0.yn_m lpopamp_core_0.sliceA_0.zn_m 11.2462f
C134 lpopamp_core_0.sliceB_0.bnb lpopamp_core_0.sliceB_0.zp_m 2.8492f
C135 lpopamp_core_0.sliceA_0.zp_m out 1.94796f
C136 lpopamp_core_0.sliceB_1.yp_m avdd 22.3771f
C137 zn_p lpopamp_core_0.sliceB_1.zn_m 3.47337f
C138 lpopamp_core_0.sliceB_1.bnb lpopamp_core_0.sliceB_1.bna 7.13374f
C139 lpopamp_core_0.sliceB_1.bpa lpopamp_core_0.sliceB_1.yp_m 1.31028f
C140 lpopamp_core_0.sliceA_1.bpa lpopamp_core_0.sliceA_1.zp_m 1.6741f
C141 lpopamp_core_0.sliceA_1.yn_p in_m 5.48943f
C142 lpopamp_core_0.sliceA_1.bna en 1.86118f
C143 lpopamp_core_0.sliceB_0.bpb a_23850_4150# 2.25051f
C144 lpopamp_core_0.sliceB_0.zn_m a_23850_4150# 2.88641f
C145 lpopamp_core_0.sliceA_1.yn_m in_p 4.02283f
C146 lpopamp_core_0.sliceA_1.yp_m avdd 18.1177f
C147 lpopamp_core_0.sliceB_0.bpb lpopamp_core_0.sliceB_0.bpa_r 12.0076f
C148 lpopamp_core_0.sliceB_0.zn_m out 3.58001f
C149 lpopamp_core_0.sliceB_0.yn_p out 1.96732f
C150 zn_p zp_p 0.28191p
C151 lpopamp_core_0.sliceA_0.bnb a_20050_100# 4.357f
C152 lpopamp_core_0.sliceB_1.enb lpopamp_core_0.sliceB_1.zn_m 1.21778f
C153 a_23850_2500# avdd 1.96446f
C154 zp_p lpopamp_core_0.sliceA_0.zp_m 5.40188f
C155 lpopamp_core_0.sliceA_1.bpa en 2.43842f
C156 lpopamp_core_0.sliceA_1.bpb lpopamp_core_0.sliceA_1.zp_m 1.50171f
C157 lpopamp_core_0.sliceB_0.yn_m in_p 4.02283f
C158 lpopamp_core_0.sliceA_1.zn_m a_22450_11850# 2.88641f
C159 lpopamp_core_0.sliceA_0.xn in_p 2.45714f
C160 lpopamp_core_0.sliceB_0.bpa a_22450_4150# 1.61108f
C161 zn_p in_p 2.79878f
C162 lpopamp_core_0.sliceB_1.yn_m out 2.26168f
C163 zn_p lpopamp_core_0.sliceA_0.yn_m 1.92524f
C164 zp_p lpopamp_core_0.sliceB_0.bpb 3.30671f
C165 lpopamp_core_0.sliceA_1.bna lpopamp_core_0.sliceA_1.bpa 1.58919f
C166 lpopamp_core_0.sliceB_1.bpb lpopamp_core_0.sliceB_1.zn_m 4.69389f
C167 zn_p lpopamp_core_0.sliceA_1.enb 1.99594f
C168 lpopamp_core_0.sliceA_1.zn_m avdd 3.68638f
C169 lpopamp_core_0.sliceB_1.yn_m lpopamp_core_0.sliceB_1.zn_m 12.14f
C170 lpopamp_core_0.sliceB_0.bnb lpopamp_core_0.sliceB_0.bpa 3.32557f
C171 lpopamp_core_0.sliceB_0.bpa_l avdd 11.6445f
C172 zn_p lpopamp_core_0.sliceB_0.bnb 2.61587f
C173 lpopamp_core_0.sliceA_0.xn in_m 2.45959f
C174 zn_p in_m 4.0988f
C175 a_20050_14250# lpopamp_core_0.sliceA_1.zp_m 1.38781f
C176 lpopamp_core_0.sliceA_0.bpa lpopamp_core_0.sliceA_0.zp_m 1.6741f
C177 zp_p lpopamp_core_0.sliceB_1.bpb 3.30671f
C178 a_23850_11850# avdd 1.96446f
C179 lpopamp_core_0.sliceB_0.bpb a_22450_4150# 2.25051f
C180 lpopamp_core_0.sliceB_0.zn_m a_22450_4150# 2.88641f
C181 lpopamp_core_0.sliceB_0.yp_p avdd 14.6863f
C182 lpopamp_core_0.sliceA_0.zp_m lpopamp_core_0.sliceA_0.yp_m 16.9076f
C183 lpopamp_core_0.sliceA_0.bpa a_22450_2500# 1.61108f
C184 lpopamp_core_0.sliceA_1.bpa_r avdd 11.5993f
C185 lpopamp_core_0.sliceA_0.xp in_p 2.8357f
C186 lpopamp_core_0.sliceA_1.bna lpopamp_core_0.sliceA_1.bpb 1.58919f
C187 lpopamp_core_0.sliceB_0.bna lpopamp_core_0.sliceB_0.bpa 1.58919f
C188 zp_p lpopamp_core_0.sliceA_0.bnb 2.21812f
C189 lpopamp_core_0.sliceA_0.xp lpopamp_core_0.sliceA_0.yn_m 3.56806f
C190 lpopamp_core_0.sliceB_0.bpa en 2.43842f
C191 lpopamp_core_0.sliceB_0.bnb lpopamp_core_0.sliceB_0.zn_m 1.3099f
C192 lpopamp_core_0.sliceA_1.bnb lpopamp_core_0.sliceA_1.bna_ 10.5436f
C193 lpopamp_core_0.sliceA_0.bpa lpopamp_core_0.sliceA_0.bna 1.58919f
C194 zn_p en 1.02966f
C195 lpopamp_core_0.sliceA_1.bnb zp_p 2.21812f
C196 lpopamp_core_0.sliceB_0.yn_p in_m 5.48943f
C197 lpopamp_core_0.sliceB_1.yn_m in_p 4.02283f
C198 lpopamp_core_0.sliceA_1.bpa lpopamp_core_0.sliceA_1.bpb 9.77074f
C199 lpopamp_core_0.sliceA_1.xp in_p 2.8357f
C200 lpopamp_core_0.sliceA_0.bpa lpopamp_core_0.sliceA_0.xp 4.53548f
C201 zp_p lpopamp_core_0.sliceB_1.yp_m 6.47848f
C202 lpopamp_core_0.sliceA_0.xp in_m 2.8345f
C203 lpopamp_core_0.sliceB_1.enb lpopamp_core_0.sliceB_1.bna 2.95512f
C204 lpopamp_core_0.sliceB_1.bpb lpopamp_core_0.sliceB_1.zp_m 1.50171f
C205 lpopamp_core_0.sliceA_0.bpb avdd 74.6438f
C206 lpopamp_core_0.sliceA_1.yp_p avdd 16.2251f
C207 lpopamp_core_0.sliceB_0.bna lpopamp_core_0.sliceB_0.bpb 1.58919f
C208 lpopamp_core_0.sliceB_0.enb lpopamp_core_0.sliceB_0.bnb 8.31444f
C209 lpopamp_core_0.sliceB_1.bpb a_22450_10200# 2.25051f
C210 lpopamp_core_0.sliceA_1.bna a_20050_14250# 1.84008f
C211 lpopamp_core_0.sliceA_0.yn_p avdd 2.13191f
C212 lpopamp_core_0.sliceB_1.enb en 5.87088f
C213 lpopamp_core_0.sliceB_0.xp avdd 5.13125f
C214 zn_p lpopamp_core_0.sliceB_1.bnb 2.61587f
C215 lpopamp_core_0.sliceA_1.yp_m zp_p 6.56825f
C216 lpopamp_core_0.sliceA_0.bna en 1.86118f
C217 lpopamp_core_0.sliceA_1.bnb lpopamp_core_0.sliceA_1.enb 8.31444f
C218 lpopamp_core_0.sliceB_0.bpa lpopamp_core_0.sliceB_0.zp_m 1.63057f
C219 lpopamp_core_0.sliceB_0.bnb a_20050_6550# 4.357f
C220 lpopamp_core_0.sliceB_1.yp_m in_p 4.19047f
C221 lpopamp_core_0.sliceA_1.xp in_m 2.8345f
C222 lpopamp_core_0.sliceA_1.zn_m out 3.58001f
C223 lpopamp_core_0.sliceA_0.bpa lpopamp_core_0.sliceA_0.bnb 3.32557f
C224 lpopamp_core_0.sliceB_1.bpa_r avdd 11.5872f
C225 lpopamp_core_0.sliceB_1.bpb lpopamp_core_0.sliceB_1.bna 1.58919f
C226 lpopamp_core_0.sliceB_1.bpa_l lpopamp_core_0.sliceB_1.bpb 11.917f
C227 lpopamp_core_0.sliceA_0.tihi avdd 27.3827f
C228 lpopamp_core_0.sliceB_1.yn_p avdd 2.27039f
C229 a_22450_11850# avdd 1.96416f
C230 lpopamp_core_0.sliceB_0.bna lpopamp_core_0.sliceB_0.enb 2.95512f
C231 lpopamp_core_0.sliceB_1.enb lpopamp_core_0.sliceB_1.bnb 8.31444f
C232 lpopamp_core_0.sliceB_1.zp_m lpopamp_core_0.sliceB_1.yp_m 17.6411f
C233 lpopamp_core_0.sliceA_0.yp_p avdd 16.2251f
C234 lpopamp_core_0.sliceA_1.yp_m in_p 4.21111f
C235 lpopamp_core_0.sliceA_1.xn in_p 2.45714f
C236 lpopamp_core_0.sliceA_1.bnb lpopamp_core_0.sliceA_1.zp_m 2.8492f
C237 zn_p lpopamp_core_0.sliceA_0.zn_m 3.47337f
C238 lpopamp_core_0.sliceB_0.enb en 5.87088f
C239 lpopamp_core_0.sliceB_1.xp lpopamp_core_0.sliceB_1.yn_m 3.56806f
C240 lpopamp_core_0.sliceB_0.bna a_20050_6550# 1.84008f
C241 lpopamp_core_0.sliceB_0.yp_p out 1.25527f
C242 lpopamp_core_0.sliceB_1.bpa avdd 0.11889p
C243 a_22450_2500# lpopamp_core_0.sliceA_0.zn_m 2.88641f
C244 lpopamp_core_0.sliceB_0.bpb lpopamp_core_0.sliceB_0.zp_m 1.50171f
C245 lpopamp_core_0.sliceB_1.yp_p avdd 14.6863f
C246 lpopamp_core_0.sliceB_1.bnb lpopamp_core_0.sliceB_1.bna_ 10.5436f
C247 lpopamp_core_0.sliceA_1.bpb lpopamp_core_0.sliceA_1.bpa_l 11.917f
C248 zn_p lpopamp_core_0.sliceA_1.bpb 2.98212f
C249 lpopamp_core_0.sliceA_1.xn in_m 2.45959f
C250 zn_p lpopamp_core_0.sliceA_1.yn_m 1.92524f
C251 lpopamp_core_0.sliceA_1.yp_m lpopamp_core_0.sliceA_1.zp_m 16.9076f
C252 lpopamp_core_0.sliceB_0.yp_m avdd 22.3771f
C253 lpopamp_core_0.sliceA_0.bpa a_23850_2500# 1.61069f
C254 lpopamp_core_0.sliceA_1.zn_m lpopamp_core_0.sliceA_1.enb 1.21778f
C255 lpopamp_core_0.sliceA_1.bnb lpopamp_core_0.sliceA_1.bna 7.13374f
C256 lpopamp_core_0.sliceA_1.yp_p out 1.25527f
C257 lpopamp_core_0.sliceA_1.bpa lpopamp_core_0.sliceA_1.xp 4.53548f
C258 a_20050_6550# lpopamp_core_0.sliceB_0.zp_m 1.38781f
C259 lpopamp_core_0.sliceA_0.yn_p out 1.96732f
C260 lpopamp_core_0.sliceA_1.yn_p lpopamp_core_0.sliceA_1.xp 3.56806f
C261 lpopamp_core_0.sliceB_1.zp_m a_20050_7800# 1.38781f
C262 zn_p lpopamp_core_0.sliceB_0.yn_m 1.9263f
C263 lpopamp_core_0.sliceB_0.xn in_p 2.45776f
C264 lpopamp_core_0.sliceA_1.bnb lpopamp_core_0.sliceA_1.bpa 3.32557f
C265 lpopamp_core_0.sliceA_0.bnb lpopamp_core_0.sliceA_0.zn_m 1.3099f
C266 lpopamp_core_0.sliceB_1.yn_p out 1.96732f
C267 lpopamp_core_0.sliceB_1.bpb a_23850_10200# 2.25051f
C268 lpopamp_core_0.sliceA_1.bna lpopamp_core_0.sliceA_1.xn 1.80641f
C269 zp_p lpopamp_core_0.sliceA_0.bpb 3.30671f
C270 a_23850_4150# avdd 2.02756f
C271 lpopamp_core_0.sliceB_1.bna a_20050_7800# 1.84008f
C272 lpopamp_core_0.sliceA_0.yp_p out 1.25527f
C273 lpopamp_core_0.sliceB_1.yn_p lpopamp_core_0.sliceB_1.zn_m 12.304f
C274 lpopamp_core_0.sliceB_0.bpa lpopamp_core_0.sliceB_0.bpb 9.77074f
C275 lpopamp_core_0.sliceB_0.zn_m lpopamp_core_0.sliceB_0.yn_m 12.14f
C276 lpopamp_core_0.sliceB_0.bpa_r avdd 11.5872f
C277 zn_p lpopamp_core_0.sliceB_1.enb 1.99594f
C278 avdd out 77.45271f
C279 lpopamp_core_0.sliceA_1.yn_m lpopamp_core_0.sliceA_1.xp 3.56806f
C280 lpopamp_core_0.sliceA_0.bna lpopamp_core_0.sliceA_0.xn 1.80641f
C281 zn_p lpopamp_core_0.sliceB_0.bpb 2.98212f
C282 zn_p lpopamp_core_0.sliceB_0.zn_m 3.47337f
C283 lpopamp_core_0.sliceB_0.yp_p in_m 2.7765f
C284 lpopamp_core_0.sliceB_0.xn in_m 2.46021f
C285 lpopamp_core_0.sliceA_1.bpa lpopamp_core_0.sliceA_1.yp_m 1.45942f
C286 lpopamp_core_0.sliceB_1.zn_m avdd 3.9184f
C287 lpopamp_core_0.sliceA_0.bpb lpopamp_core_0.sliceA_0.bpa_r 12.0076f
C288 lpopamp_core_0.sliceB_1.yp_p out 1.25527f
C289 lpopamp_core_0.sliceB_0.xp in_p 2.8357f
C290 lpopamp_core_0.sliceB_0.bna lpopamp_core_0.sliceB_0.xn 1.80641f
C291 zn_p lpopamp_core_0.sliceB_1.bpb 2.98212f
C292 avdd ib 1.34162f
C293 lpopamp_core_0.sliceB_1.bnb a_20050_7800# 4.357f
C294 zn_p lpopamp_core_0.sliceB_0.enb 1.99594f
C295 lpopamp_core_0.sliceB_0.zn_m lpopamp_core_0.sliceB_0.bpb 4.69389f
C296 zp_p avdd 0.10975p
C297 lpopamp_core_0.sliceA_0.zn_m a_23850_2500# 2.88641f
C298 lpopamp_core_0.sliceB_0.zn_m lpopamp_core_0.sliceB_0.yn_p 12.304f
C299 zn_p lpopamp_core_0.sliceB_1.yn_m 1.9263f
C300 lpopamp_core_0.sliceA_0.bpa lpopamp_core_0.sliceA_0.bpb 9.77074f
C301 lpopamp_core_0.sliceA_0.enb en 5.87088f
C302 zn_p lpopamp_core_0.sliceA_0.bnb 2.61433f
C303 lpopamp_core_0.sliceA_1.yp_p in_m 2.7765f
C304 lpopamp_core_0.sliceA_0.zp_m lpopamp_core_0.sliceA_0.bnb 2.8492f
C305 lpopamp_core_0.sliceA_1.yp_p lpopamp_core_0.sliceA_1.zp_m 25.4502f
C306 lpopamp_core_0.sliceA_1.tihi avdd 27.3827f
C307 lpopamp_core_0.sliceA_0.yn_p in_m 5.48943f
C308 lpopamp_core_0.sliceB_0.xp in_m 2.8345f
C309 lpopamp_core_0.sliceA_1.zn_m lpopamp_core_0.sliceA_1.yn_p 13.5782f
C310 lpopamp_core_0.sliceA_0.bpa_r avdd 11.5993f
C311 lpopamp_core_0.sliceA_1.bnb zn_p 2.61433f
C312 lpopamp_core_0.sliceA_1.bnb a_20050_14250# 4.357f
C313 avdd in_p 28.1018f
C314 lpopamp_core_0.sliceB_0.enb lpopamp_core_0.sliceB_0.zn_m 1.21778f
C315 lpopamp_core_0.sliceB_0.bna_ lpopamp_core_0.sliceB_0.bnb 10.5436f
C316 zp_p lpopamp_core_0.sliceB_0.yp_m 6.47848f
C317 lpopamp_core_0.sliceA_0.yn_m avdd 2.13191f
C318 a_22450_4150# avdd 2.02726f
C319 out avss 1.58673p
C320 ib avss 32.0256f
C321 avdd avss 0.36282p
C322 a_9550_100# avss 32.09846f
C323 a_24450_700# avss 60.87f
C324 a_20050_100# avss 3.4955f
C325 lpopamp_core_0.sliceA_0.xn avss 3.78329f
C326 a_8650_700# avss 10.66626f
C327 a_8550_700# avss 10.67022f
C328 a_4050_700# avss 64.75334f
C329 a_22450_2500# avss 1.72688f
C330 lpopamp_core_0.sliceA_0.yn_m avss 16.3703f
C331 lpopamp_core_0.sliceA_0.yn_p avss 76.0859f
C332 lpopamp_core_0.sliceA_0.yp_m avss 2.64788f
C333 lpopamp_core_0.sliceA_0.yp_p avss 6.07978f
C334 lpopamp_core_0.sliceB_0.xp avss 89.48367f
C335 a_29350_6550# avss 11.439f
C336 a_27350_6550# avss 60.49358f
C337 a_12650_6550# avss 10.65524f
C338 a_12550_6550# avss 10.64384f
C339 a_8450_6550# avss 16.03013f
C340 a_8350_6550# avss 16.03839f
C341 a_28950_7150# avss 0.17173p
C342 a_28750_7150# avss 11.51076f
C343 a_21650_7150# avss 64.47514f
C344 a_20050_6550# avss 67.90382f
C345 lpopamp_core_0.sliceB_0.yn_p avss 0.10293p
C346 lpopamp_core_0.sliceB_0.yn_m avss 18.0502f
C347 lpopamp_core_0.sliceB_0.yp_p avss 3.11376f
C348 lpopamp_core_0.sliceB_0.yp_m avss 5.59554f
C349 lpopamp_core_0.sliceB_0.xn avss 3.76894f
C350 a_11350_7150# avss 31.95826f
C351 a_29150_7800# avss 11.49293f
C352 a_25250_7800# avss 60.5175f
C353 a_15650_7800# avss 64.47514f
C354 a_13750_7800# avss 87.04227f
C355 a_10550_7800# avss 31.95826f
C356 a_20050_7800# avss 3.46681f
C357 lpopamp_core_0.sliceB_1.xn avss 68.20594f
C358 a_12550_8400# avss 26.61484f
C359 a_12450_8400# avss 26.60658f
C360 lpopamp_core_0.sliceB_1.yn_p avss 13.4898f
C361 lpopamp_core_0.sliceB_1.yn_m avss 78.5212f
C362 lpopamp_core_0.sliceB_1.xp avss 1.74363f
C363 lpopamp_core_0.sliceB_1.yp_p avss 6.05264f
C364 lpopamp_core_0.sliceB_1.yp_m avss 89.68266f
C365 lpopamp_core_0.sliceA_1.xp avss 1.74722f
C366 a_28550_14250# avss 41.69233f
C367 a_25750_14250# avss 60.85057f
C368 a_10550_14250# avss 32.1174f
C369 a_20050_14250# avss 3.4955f
C370 lpopamp_core_0.sliceA_1.yn_m avss 77.1983f
C371 lpopamp_core_0.sliceA_1.yn_p avss 15.2579f
C372 lpopamp_core_0.sliceA_1.yp_m avss 5.60432f
C373 lpopamp_core_0.sliceA_1.yp_p avss 3.12334f
C374 lpopamp_core_0.sliceA_1.xn avss 3.78329f
C375 a_8650_14850# avss 10.64961f
C376 a_8550_14850# avss 10.65429f
C377 a_4050_14850# avss 64.73729f
.ends
