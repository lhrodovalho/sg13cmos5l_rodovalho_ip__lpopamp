* NGSPICE file created from slot10_wrapper.ext - technology: ihp-sg13cmos5l

.subckt lvlshifter in out vddlo vddhi vss
X0 a_1050_450# ym a_950_450# vddhi sg13_hv_pmos ad=0.15625p pd=1.5u as=0.15625p ps=1.5u w=2.5u l=0.5u
X1 a_750_450# ym vddhi vddhi sg13_hv_pmos ad=0.15625p pd=1.5u as=0.3125p ps=3u w=2.5u l=0.5u
X2 vss xm yp vss sg13_hv_nmos ad=0.15625p pd=1.5u as=0.15625p ps=1.5u w=2.5u l=0.5u
X3 vss xm yp vss sg13_hv_nmos ad=0.15625p pd=1.5u as=0.15625p ps=1.5u w=2.5u l=0.5u
X4 out ym vddhi vddhi sg13_hv_pmos ad=0.15625p pd=1.5u as=0.15625p ps=1.5u w=2.5u l=0.5u
X5 vss xm yp vss sg13_hv_nmos ad=0.3125p pd=3u as=0.15625p ps=1.5u w=2.5u l=0.5u
X6 yp xm vss vss sg13_hv_nmos ad=0.15625p pd=1.5u as=0.3125p ps=3u w=2.5u l=0.5u
X7 a_1650_450# yp vddhi vddhi sg13_hv_pmos ad=0.15625p pd=1.5u as=0.3125p ps=3u w=2.5u l=0.5u
X8 yp xm vss vss sg13_hv_nmos ad=0.15625p pd=1.5u as=0.15625p ps=1.5u w=2.5u l=0.5u
X9 vddlo xm xp vddlo sg13_lv_pmos ad=0.3125p pd=3u as=0.15625p ps=1.5u w=2.5u l=0.5u
X10 a_1350_450# xm a_1250_450# vddhi sg13_hv_pmos ad=0.15625p pd=1.5u as=0.15625p ps=1.5u w=2.5u l=0.5u
X11 xm in vddlo vddlo sg13_lv_pmos ad=0.15625p pd=1.5u as=0.3125p ps=3u w=2.5u l=0.5u
X12 out ym vddhi vddhi sg13_hv_pmos ad=0.15625p pd=1.5u as=0.3125p ps=3u w=2.5u l=0.5u
X13 out ym a_2550_n450# vss sg13_hv_nmos ad=0.15625p pd=1.5u as=0.15625p ps=1.5u w=2.5u l=0.5u
X14 a_100_n450# xm vss vss sg13_lv_nmos ad=0.15625p pd=1.5u as=0.3125p ps=3u w=2.5u l=0.5u
X15 vss ym a_2750_n450# vss sg13_hv_nmos ad=0.3125p pd=3u as=0.15625p ps=1.5u w=2.5u l=0.5u
X16 a_2250_450# xp a_2150_450# vddhi sg13_hv_pmos ad=0.15625p pd=1.5u as=0.15625p ps=1.5u w=2.5u l=0.5u
X17 a_1950_450# yp a_1850_450# vddhi sg13_hv_pmos ad=0.15625p pd=1.5u as=0.15625p ps=1.5u w=2.5u l=0.5u
X18 vss xp ym vss sg13_hv_nmos ad=0.15625p pd=1.5u as=0.15625p ps=1.5u w=2.5u l=0.5u
X19 vss xp ym vss sg13_hv_nmos ad=0.3125p pd=3u as=0.15625p ps=1.5u w=2.5u l=0.5u
X20 a_1150_450# xm a_1050_450# vddhi sg13_hv_pmos ad=0.15625p pd=1.5u as=0.15625p ps=1.5u w=2.5u l=0.5u
X21 a_n200_n450# in vss vss sg13_lv_nmos ad=0.15625p pd=1.5u as=0.3125p ps=3u w=2.5u l=0.5u
X22 a_850_450# ym a_750_450# vddhi sg13_hv_pmos ad=0.15625p pd=1.5u as=0.15625p ps=1.5u w=2.5u l=0.5u
X23 ym xp vss vss sg13_hv_nmos ad=0.15625p pd=1.5u as=0.3125p ps=3u w=2.5u l=0.5u
X24 vddhi ym out vddhi sg13_hv_pmos ad=0.3125p pd=3u as=0.15625p ps=1.5u w=2.5u l=0.5u
X25 ym xp vss vss sg13_hv_nmos ad=0.15625p pd=1.5u as=0.15625p ps=1.5u w=2.5u l=0.5u
X26 a_2050_450# xp a_1950_450# vddhi sg13_hv_pmos ad=0.15625p pd=1.5u as=0.15625p ps=1.5u w=2.5u l=0.5u
X27 yp xm vss vss sg13_hv_nmos ad=0.15625p pd=1.5u as=0.15625p ps=1.5u w=2.5u l=0.5u
X28 a_1750_450# yp a_1650_450# vddhi sg13_hv_pmos ad=0.15625p pd=1.5u as=0.15625p ps=1.5u w=2.5u l=0.5u
X29 yp xm vss vss sg13_hv_nmos ad=0.15625p pd=1.5u as=0.15625p ps=1.5u w=2.5u l=0.5u
X30 yp xm a_1350_450# vddhi sg13_hv_pmos ad=0.3125p pd=3u as=0.15625p ps=1.5u w=2.5u l=0.5u
X31 vddhi ym out vddhi sg13_hv_pmos ad=0.15625p pd=1.5u as=0.15625p ps=1.5u w=2.5u l=0.5u
X32 vss xm yp vss sg13_hv_nmos ad=0.15625p pd=1.5u as=0.15625p ps=1.5u w=2.5u l=0.5u
X33 ym xp a_2250_450# vddhi sg13_hv_pmos ad=0.3125p pd=3u as=0.15625p ps=1.5u w=2.5u l=0.5u
X34 a_2550_n450# ym vss vss sg13_hv_nmos ad=0.15625p pd=1.5u as=0.3125p ps=3u w=2.5u l=0.5u
X35 xp xm vddlo vddlo sg13_lv_pmos ad=0.15625p pd=1.5u as=0.3125p ps=3u w=2.5u l=0.5u
X36 xp xm a_100_n450# vss sg13_lv_nmos ad=0.3125p pd=3u as=0.15625p ps=1.5u w=2.5u l=0.5u
X37 a_1250_450# xm a_1150_450# vddhi sg13_hv_pmos ad=0.15625p pd=1.5u as=0.15625p ps=1.5u w=2.5u l=0.5u
X38 a_2750_n450# ym out vss sg13_hv_nmos ad=0.15625p pd=1.5u as=0.15625p ps=1.5u w=2.5u l=0.5u
X39 vddlo in xm vddlo sg13_lv_pmos ad=0.3125p pd=3u as=0.15625p ps=1.5u w=2.5u l=0.5u
X40 a_950_450# ym a_850_450# vddhi sg13_hv_pmos ad=0.15625p pd=1.5u as=0.15625p ps=1.5u w=2.5u l=0.5u
X41 ym xp vss vss sg13_hv_nmos ad=0.15625p pd=1.5u as=0.15625p ps=1.5u w=2.5u l=0.5u
X42 ym xp vss vss sg13_hv_nmos ad=0.15625p pd=1.5u as=0.15625p ps=1.5u w=2.5u l=0.5u
X43 a_2150_450# xp a_2050_450# vddhi sg13_hv_pmos ad=0.15625p pd=1.5u as=0.15625p ps=1.5u w=2.5u l=0.5u
X44 xm in a_n200_n450# vss sg13_lv_nmos ad=0.3125p pd=3u as=0.15625p ps=1.5u w=2.5u l=0.5u
X45 a_1850_450# yp a_1750_450# vddhi sg13_hv_pmos ad=0.15625p pd=1.5u as=0.15625p ps=1.5u w=2.5u l=0.5u
X46 vss xp ym vss sg13_hv_nmos ad=0.15625p pd=1.5u as=0.15625p ps=1.5u w=2.5u l=0.5u
X47 vss xp ym vss sg13_hv_nmos ad=0.15625p pd=1.5u as=0.15625p ps=1.5u w=2.5u l=0.5u
.ends

.subckt lpopamp_sliceB in_m in_p out avss avdd ib en zp_p zn_p
X0 a_16500_6600# bna_ a_16300_6600# avss sg13_hv_nmos ad=1.125p pd=5u as=1.125p ps=5u w=9u l=1u
X1 yp_p in_m a_28900_6600# avss sg13_hv_nmos ad=1.125p pd=5u as=1.125p ps=5u w=9u l=1u
X2 zp_m bnb a_40900_5400# avss sg13_hv_nmos ad=1.125p pd=5u as=1.125p ps=5u w=9u l=1u
X3 zn_m zn_m a_46500_5400# avss sg13_hv_nmos ad=1.125p pd=5u as=1.125p ps=5u w=9u l=1u
X4 zp_p bpb zn_p avdd sg13_hv_pmos ad=1.125p pd=5u as=1.125p ps=5u w=9u l=1u
X5 a_21100_1800# bpa_r a_20900_1800# avdd sg13_hv_pmos ad=1.125p pd=5u as=1.125p ps=5u w=9u l=1u
X6 yn_m zn_m a_50900_6600# avss sg13_hv_nmos ad=1.125p pd=5u as=1.125p ps=5u w=9u l=1u
X7 avss zn_p a_56500_6600# avss sg13_hv_nmos ad=1.125p pd=5u as=1.125p ps=5u w=9u l=1u
X8 avdd zp_p out avdd sg13_hv_pmos ad=1.125p pd=5u as=1.125p ps=5u w=9u l=1u
X9 bpa en avdd avdd sg13_hv_pmos ad=1.125p pd=5u as=1.125p ps=5u w=9u l=3u
X10 a_46700_600# bpb zn_m avdd sg13_hv_pmos ad=1.125p pd=5u as=1.125p ps=5u w=9u l=1u
X11 avss zn_p a_58100_5400# avss sg13_hv_nmos ad=1.125p pd=5u as=1.125p ps=5u w=9u l=1u
X12 zp_p bnb a_52500_5400# avss sg13_hv_nmos ad=1.125p pd=5u as=1.125p ps=5u w=9u l=1u
X13 a_39100_5400# bnb a_41300_6600# avss sg13_hv_nmos ad=1.125p pd=5u as=1.125p ps=5u w=9u l=1u
X14 bpb bpb bpa_l avdd sg13_hv_pmos ad=1.125p pd=5u as=1.125p ps=5u w=9u l=1u
X15 avdd bpa xp avdd sg13_hv_pmos ad=1.125p pd=5u as=1.125p ps=5u w=9u l=7u
X16 bpb bpb bpa_r avdd sg13_hv_pmos ad=1.125p pd=5u as=1.125p ps=5u w=9u l=1u
X17 zp_m zp_m yp_p avdd sg13_hv_pmos ad=1.125p pd=5u as=1.125p ps=5u w=9u l=1u
X18 bna_ bnb a_19700_6600# avss sg13_hv_nmos ad=1.125p pd=5u as=1.125p ps=5u w=9u l=1u
X19 a_16100_1800# bpa_l bpa_l avdd sg13_hv_pmos ad=1.125p pd=5u as=1.125p ps=5u w=9u l=1u
X20 bna_ bnb a_20500_5400# avss sg13_hv_nmos ad=1.125p pd=5u as=1.125p ps=5u w=9u l=1u
X21 a_21300_1800# bpa_r a_21100_1800# avdd sg13_hv_pmos ad=1.125p pd=5u as=1.125p ps=5u w=9u l=1u
X22 zp_p zp_m yp_m avdd sg13_hv_pmos ad=1.125p pd=5u as=1.125p ps=5u w=9u l=1u
X23 zp_m zp_m yp_p avdd sg13_hv_pmos ad=1.125p pd=5u as=1.125p ps=5u w=9u l=1u
X24 yp_m zp_m avdd avdd sg13_hv_pmos ad=1.125p pd=5u as=1.125p ps=5u w=9u l=7u
X25 out zp_p avdd avdd sg13_hv_pmos ad=1.125p pd=5u as=1.125p ps=5u w=9u l=1u
X26 zn_m bpb a_46700_600# avdd sg13_hv_pmos ad=1.125p pd=5u as=1.125p ps=5u w=9u l=1u
X27 out zp_p avdd avdd sg13_hv_pmos ad=1.125p pd=5u as=1.125p ps=5u w=9u l=1u
X28 avss zn_m a_33500_6600# avss sg13_hv_nmos ad=1.125p pd=5u as=1.125p ps=5u w=9u l=7u
X29 a_39300_6600# bnb a_39100_5400# avss sg13_hv_nmos ad=1.125p pd=5u as=1.125p ps=5u w=9u l=1u
X30 a_44900_6600# zn_m yn_p avss sg13_hv_nmos ad=1.125p pd=5u as=1.125p ps=5u w=9u l=1u
X31 a_15500_6600# bna_ a_15300_6600# avss sg13_hv_nmos ad=1.125p pd=5u as=1.125p ps=5u w=9u l=1u
X32 a_28100_6600# in_m xn avss sg13_hv_nmos ad=1.125p pd=5u as=1.125p ps=5u w=9u l=1u
X33 a_40100_5400# bnb a_39100_5400# avss sg13_hv_nmos ad=1.125p pd=5u as=1.125p ps=5u w=9u l=1u
X34 bpa_l bpb bpb avdd sg13_hv_pmos ad=1.125p pd=5u as=1.125p ps=5u w=9u l=1u
X35 a_45700_5400# zn_m yn_p avss sg13_hv_nmos ad=1.125p pd=5u as=1.125p ps=5u w=9u l=1u
X36 a_24100_5400# bna_ a_23900_5400# avss sg13_hv_nmos ad=1.125p pd=5u as=1.125p ps=5u w=9u l=1u
X37 a_30300_5400# bna xn avss sg13_hv_nmos ad=1.125p pd=5u as=1.125p ps=5u w=9u l=7u
X38 a_16300_1800# bpa_l a_16100_1800# avdd sg13_hv_pmos ad=1.125p pd=5u as=1.125p ps=5u w=9u l=1u
X39 avss en enb avss sg13_hv_nmos ad=1.125p pd=5u as=1.125p ps=5u w=9u l=3u
X40 avdd bpa_r a_21300_1800# avdd sg13_hv_pmos ad=1.125p pd=5u as=1.125p ps=5u w=9u l=1u
X41 a_57300_5400# zn_p out avss sg13_hv_nmos ad=1.125p pd=5u as=1.125p ps=5u w=9u l=1u
X42 a_51700_5400# bnb zn_p avss sg13_hv_nmos ad=1.125p pd=5u as=1.125p ps=5u w=9u l=1u
X43 a_40500_6600# bnb zp_m avss sg13_hv_nmos ad=1.125p pd=5u as=1.125p ps=5u w=9u l=1u
X44 yp_m zp_m zp_p avdd sg13_hv_pmos ad=1.125p pd=5u as=1.125p ps=5u w=9u l=1u
X45 yp_p zp_m zp_m avdd sg13_hv_pmos ad=1.125p pd=5u as=1.125p ps=5u w=9u l=1u
X46 yp_m zp_m zp_p avdd sg13_hv_pmos ad=1.125p pd=5u as=1.125p ps=5u w=9u l=1u
X47 avdd zp_m yp_p avdd sg13_hv_pmos ad=1.125p pd=5u as=1.125p ps=5u w=9u l=7u
X48 a_24500_6600# bna_ a_24300_6600# avss sg13_hv_nmos ad=1.125p pd=5u as=1.125p ps=5u w=9u l=1u
X49 avdd en bpa avdd sg13_hv_pmos ad=1.125p pd=5u as=1.125p ps=5u w=9u l=3u
X50 a_18900_6600# bnb bnb avss sg13_hv_nmos ad=1.125p pd=5u as=1.125p ps=5u w=9u l=1u
X51 a_46700_600# bpb zn_m avdd sg13_hv_pmos ad=1.125p pd=5u as=1.125p ps=5u w=9u l=1u
X52 avdd zp_p out avdd sg13_hv_pmos ad=1.125p pd=5u as=1.125p ps=5u w=9u l=1u
X53 avdd tihi tihi avdd sg13_hv_pmos ad=1.125p pd=5u as=1.125p ps=5u w=9u l=19u
X54 zp_p zp_m yp_m avdd sg13_hv_pmos ad=1.125p pd=5u as=1.125p ps=5u w=9u l=1u
X55 a_43900_600# bpb zn_m avdd sg13_hv_pmos ad=1.125p pd=5u as=1.125p ps=5u w=9u l=1u
X56 avdd bpa bpa avdd sg13_hv_pmos ad=1.125p pd=5u as=1.125p ps=5u w=9u l=7u
X57 avss zn_p a_58900_6600# avss sg13_hv_nmos ad=1.125p pd=5u as=1.125p ps=5u w=9u l=1u
X58 a_16500_1800# bpa_l a_16300_1800# avdd sg13_hv_pmos ad=1.125p pd=5u as=1.125p ps=5u w=9u l=1u
X59 yn_m in_p xp avdd sg13_hv_pmos ad=1.125p pd=5u as=1.125p ps=5u w=9u l=1u
X60 bpa_r bpb bpb avdd sg13_hv_pmos ad=1.125p pd=5u as=1.125p ps=5u w=9u l=1u
X61 xn in_p a_26900_6600# avss sg13_hv_nmos ad=1.125p pd=5u as=1.125p ps=5u w=9u l=1u
X62 avdd zp_m yp_p avdd sg13_hv_pmos ad=1.125p pd=5u as=1.125p ps=5u w=9u l=7u
X63 zp_p zp_m yp_m avdd sg13_hv_pmos ad=1.125p pd=5u as=1.125p ps=5u w=9u l=1u
X64 a_39100_5400# bnb a_39700_5400# avss sg13_hv_nmos ad=1.125p pd=5u as=1.125p ps=5u w=9u l=1u
X65 a_11100_5400# bna bpa avss sg13_hv_nmos ad=1.125p pd=5u as=1.125p ps=5u w=9u l=7u
X66 bna_ bnb a_22900_5400# avss sg13_hv_nmos ad=1.125p pd=5u as=1.125p ps=5u w=9u l=1u
X67 xn in_m a_28500_5400# avss sg13_hv_nmos ad=1.125p pd=5u as=1.125p ps=5u w=9u l=1u
X68 a_43900_600# bpb zn_m avdd sg13_hv_pmos ad=1.125p pd=5u as=1.125p ps=5u w=9u l=1u
X69 out zp_p avdd avdd sg13_hv_pmos ad=1.125p pd=5u as=1.125p ps=5u w=9u l=1u
X70 avdd bpa a_43900_600# avdd sg13_hv_pmos ad=1.125p pd=5u as=1.125p ps=5u w=9u l=7u
X71 yp_m zp_m zp_p avdd sg13_hv_pmos ad=1.125p pd=5u as=1.125p ps=5u w=9u l=1u
X72 avdd zp_p out avdd sg13_hv_pmos ad=1.125p pd=5u as=1.125p ps=5u w=9u l=1u
X73 out zn_p a_56100_5400# avss sg13_hv_nmos ad=1.125p pd=5u as=1.125p ps=5u w=9u l=1u
X74 zn_p zn_m a_50500_5400# avss sg13_hv_nmos ad=1.125p pd=5u as=1.125p ps=5u w=9u l=1u
X75 bpb bpb bpa_l avdd sg13_hv_pmos ad=1.125p pd=5u as=1.125p ps=5u w=9u l=1u
X76 xp in_p yn_m avdd sg13_hv_pmos ad=1.125p pd=5u as=1.125p ps=5u w=9u l=1u
X77 bpb bpb bpa_r avdd sg13_hv_pmos ad=1.125p pd=5u as=1.125p ps=5u w=9u l=1u
X78 bnb bnb a_17700_6600# avss sg13_hv_nmos ad=1.125p pd=5u as=1.125p ps=5u w=9u l=1u
X79 a_23500_6600# bna_ a_23300_6600# avss sg13_hv_nmos ad=1.125p pd=5u as=1.125p ps=5u w=9u l=1u
X80 avss zn_m a_47900_5400# avss sg13_hv_nmos ad=1.125p pd=5u as=1.125p ps=5u w=9u l=7u
X81 avdd zp_m yp_p avdd sg13_hv_pmos ad=1.125p pd=5u as=1.125p ps=5u w=9u l=7u
X82 yp_m zp_m zp_p avdd sg13_hv_pmos ad=1.125p pd=5u as=1.125p ps=5u w=9u l=1u
X83 bnb bnb a_19300_5400# avss sg13_hv_nmos ad=1.125p pd=5u as=1.125p ps=5u w=9u l=1u
X84 a_58100_6600# zn_p out avss sg13_hv_nmos ad=1.125p pd=5u as=1.125p ps=5u w=9u l=1u
X85 zn_m bpb a_43900_600# avdd sg13_hv_pmos ad=1.125p pd=5u as=1.125p ps=5u w=9u l=1u
X86 zp_p zp_m yp_m avdd sg13_hv_pmos ad=1.125p pd=5u as=1.125p ps=5u w=9u l=1u
X87 out zp_p avdd avdd sg13_hv_pmos ad=1.125p pd=5u as=1.125p ps=5u w=9u l=1u
X88 avdd zp_m yp_m avdd sg13_hv_pmos ad=1.125p pd=5u as=1.125p ps=5u w=9u l=7u
X89 zn_m bpb a_46700_600# avdd sg13_hv_pmos ad=1.125p pd=5u as=1.125p ps=5u w=9u l=1u
X90 avss enb zn_p avss sg13_hv_nmos ad=2.25p pd=10u as=1.125p ps=5u w=9u l=3u
X91 a_54100_5400# zn_m zn_p avss sg13_hv_nmos ad=1.125p pd=5u as=1.125p ps=5u w=9u l=1u
X92 bpa_l bpb bpb avdd sg13_hv_pmos ad=1.125p pd=5u as=1.125p ps=5u w=9u l=1u
X93 yn_m in_p xp avdd sg13_hv_pmos ad=1.125p pd=5u as=1.125p ps=5u w=9u l=1u
X94 enb en avdd avdd sg13_hv_pmos ad=1.125p pd=5u as=2.25p ps=10u w=9u l=3u
X95 a_22100_5400# bnb bnb avss sg13_hv_nmos ad=1.125p pd=5u as=1.125p ps=5u w=9u l=1u
X96 a_27700_5400# in_p yp_m avss sg13_hv_nmos ad=1.125p pd=5u as=1.125p ps=5u w=9u l=1u
X97 yn_p in_m xp avdd sg13_hv_pmos ad=1.125p pd=5u as=1.125p ps=5u w=9u l=1u
X98 a_55100_6600# zn_m yn_m avss sg13_hv_nmos ad=1.125p pd=5u as=1.125p ps=5u w=9u l=7u
X99 a_17100_600# bpa_r a_16900_600# avdd sg13_hv_pmos ad=1.125p pd=5u as=1.125p ps=5u w=9u l=1u
X100 enb en avss avss sg13_hv_nmos ad=1.125p pd=5u as=2.25p ps=10u w=9u l=3u
X101 zn_p bpb zp_p avdd sg13_hv_pmos ad=1.125p pd=5u as=1.125p ps=5u w=9u l=1u
X102 yp_p zp_m avdd avdd sg13_hv_pmos ad=1.125p pd=5u as=1.125p ps=5u w=9u l=7u
X103 avss zn_m a_55100_5400# avss sg13_hv_nmos ad=1.125p pd=5u as=1.125p ps=5u w=9u l=7u
X104 bpa bpa avdd avdd sg13_hv_pmos ad=1.125p pd=5u as=1.125p ps=5u w=9u l=7u
X105 a_16900_6600# bnb bna_ avss sg13_hv_nmos ad=1.125p pd=5u as=1.125p ps=5u w=9u l=1u
X106 a_22500_6600# bnb bna_ avss sg13_hv_nmos ad=1.125p pd=5u as=1.125p ps=5u w=9u l=1u
X107 yn_p zn_m a_46900_5400# avss sg13_hv_nmos ad=1.125p pd=5u as=1.125p ps=5u w=9u l=1u
X108 ib en bna avss sg13_hv_nmos ad=1.125p pd=5u as=1.125p ps=5u w=9u l=3u
X109 avss bna a_11100_6600# avss sg13_hv_nmos ad=1.125p pd=5u as=1.125p ps=5u w=9u l=7u
X110 a_46700_600# bpb zn_m avdd sg13_hv_pmos ad=1.125p pd=5u as=1.125p ps=5u w=9u l=1u
X111 yp_p zp_m avdd avdd sg13_hv_pmos ad=1.125p pd=5u as=1.125p ps=5u w=9u l=7u
X112 a_57100_600# zp_p out avdd sg13_hv_pmos ad=1.125p pd=5u as=1.125p ps=5u w=9u l=1u
X113 bpb bna a_12700_5400# avss sg13_hv_nmos ad=1.125p pd=5u as=1.125p ps=5u w=9u l=7u
X114 a_18500_5400# bnb bna_ avss sg13_hv_nmos ad=1.125p pd=5u as=1.125p ps=5u w=9u l=1u
X115 out zn_p a_56900_6600# avss sg13_hv_nmos ad=1.125p pd=5u as=1.125p ps=5u w=9u l=1u
X116 avss bna a_7100_5400# avss sg13_hv_nmos ad=1.125p pd=5u as=1.125p ps=5u w=9u l=7u
X117 a_12100_600# bpa_l avdd avdd sg13_hv_pmos ad=1.125p pd=5u as=1.125p ps=5u w=9u l=1u
X118 xp in_m yn_p avdd sg13_hv_pmos ad=1.125p pd=5u as=1.125p ps=5u w=9u l=1u
X119 a_17300_600# bpa_r a_17100_600# avdd sg13_hv_pmos ad=1.125p pd=5u as=1.125p ps=5u w=9u l=1u
X120 yp_p zp_m avdd avdd sg13_hv_pmos ad=1.125p pd=5u as=1.125p ps=5u w=9u l=7u
X121 out zn_p a_58500_5400# avss sg13_hv_nmos ad=1.125p pd=5u as=1.125p ps=5u w=9u l=1u
X122 zn_p bnb a_52900_5400# avss sg13_hv_nmos ad=1.125p pd=5u as=1.125p ps=5u w=9u l=1u
X123 avdd bpa bnb avdd sg13_hv_pmos ad=1.125p pd=5u as=1.125p ps=5u w=9u l=7u
X124 bpb bpb bpa_r avdd sg13_hv_pmos ad=1.125p pd=5u as=1.125p ps=5u w=9u l=1u
X125 bnb bnb a_20900_5400# avss sg13_hv_nmos ad=1.125p pd=5u as=1.125p ps=5u w=9u l=1u
X126 yp_m in_p a_26500_5400# avss sg13_hv_nmos ad=1.125p pd=5u as=1.125p ps=5u w=9u l=1u
X127 yn_m zn_m a_53300_6600# avss sg13_hv_nmos ad=1.125p pd=5u as=1.125p ps=5u w=9u l=1u
X128 out zp_p a_57100_600# avdd sg13_hv_pmos ad=1.125p pd=5u as=1.125p ps=5u w=9u l=1u
X129 a_46700_600# bpa avdd avdd sg13_hv_pmos ad=1.125p pd=5u as=1.125p ps=5u w=9u l=7u
X130 avdd zp_m yp_p avdd sg13_hv_pmos ad=1.125p pd=5u as=1.125p ps=5u w=9u l=7u
X131 a_12300_600# bpa_l a_12100_600# avdd sg13_hv_pmos ad=1.125p pd=5u as=1.125p ps=5u w=9u l=1u
X132 xp in_p yn_m avdd sg13_hv_pmos ad=1.125p pd=5u as=1.125p ps=5u w=9u l=1u
X133 a_15900_6600# bna_ a_15700_6600# avss sg13_hv_nmos ad=1.125p pd=5u as=1.125p ps=5u w=9u l=1u
X134 bna_ bnb a_21300_6600# avss sg13_hv_nmos ad=1.125p pd=5u as=1.125p ps=5u w=9u l=1u
X135 a_39700_6600# bnb zp_m avss sg13_hv_nmos ad=1.125p pd=5u as=1.125p ps=5u w=9u l=1u
X136 a_46100_5400# zn_m zn_m avss sg13_hv_nmos ad=1.125p pd=5u as=1.125p ps=5u w=9u l=1u
X137 bpa_r bpa_r a_17300_600# avdd sg13_hv_pmos ad=1.125p pd=5u as=1.125p ps=5u w=9u l=1u
X138 bpb bpb bpa_r avdd sg13_hv_pmos ad=1.125p pd=5u as=1.125p ps=5u w=9u l=1u
X139 bpa_l bpb bpb avdd sg13_hv_pmos ad=1.125p pd=5u as=1.125p ps=5u w=9u l=1u
X140 bna_ bnb a_17300_5400# avss sg13_hv_nmos ad=1.125p pd=5u as=1.125p ps=5u w=9u l=1u
X141 a_56100_6600# zn_p avss avss sg13_hv_nmos ad=1.125p pd=5u as=1.125p ps=5u w=9u l=1u
X142 yp_m bpa avdd avdd sg13_hv_pmos ad=1.125p pd=5u as=1.125p ps=5u w=9u l=7u
X143 bpa_r bpb bpb avdd sg13_hv_pmos ad=1.125p pd=5u as=1.125p ps=5u w=9u l=1u
X144 a_4700_6600# bna avss avss sg13_hv_nmos ad=1.125p pd=5u as=1.125p ps=5u w=9u l=7u
X145 a_40900_6600# bnb a_39100_5400# avss sg13_hv_nmos ad=1.125p pd=5u as=1.125p ps=5u w=9u l=1u
X146 a_46500_6600# zn_m yn_p avss sg13_hv_nmos ad=1.125p pd=5u as=1.125p ps=5u w=9u l=1u
X147 avdd zp_p out avdd sg13_hv_pmos ad=1.125p pd=5u as=1.125p ps=5u w=9u l=1u
X148 a_57700_5400# zn_p avss avss sg13_hv_nmos ad=1.125p pd=5u as=1.125p ps=5u w=9u l=1u
X149 a_52100_5400# bnb zp_p avss sg13_hv_nmos ad=1.125p pd=5u as=1.125p ps=5u w=9u l=1u
X150 yn_p zn_m a_35100_6600# avss sg13_hv_nmos ad=1.125p pd=5u as=1.125p ps=5u w=9u l=7u
X151 yp_m zp_m zp_p avdd sg13_hv_pmos ad=1.125p pd=5u as=1.125p ps=5u w=9u l=1u
X152 avdd en zp_p avdd sg13_hv_pmos ad=2.25p pd=10u as=1.125p ps=5u w=9u l=3u
X153 a_12500_600# bpa_l a_12300_600# avdd sg13_hv_pmos ad=1.125p pd=5u as=1.125p ps=5u w=9u l=1u
X154 yn_m in_p xp avdd sg13_hv_pmos ad=1.125p pd=5u as=1.125p ps=5u w=9u l=1u
X155 a_19300_6600# bnb bna_ avss sg13_hv_nmos ad=1.125p pd=5u as=1.125p ps=5u w=9u l=1u
X156 a_25500_6600# bna avss avss sg13_hv_nmos ad=1.125p pd=5u as=1.125p ps=5u w=9u l=7u
X157 a_31900_5400# zn_m avss avss sg13_hv_nmos ad=1.125p pd=5u as=1.125p ps=5u w=9u l=7u
X158 avss zn_m a_36700_5400# avss sg13_hv_nmos ad=1.125p pd=5u as=1.125p ps=5u w=9u l=7u
X159 avss bna a_42300_5400# avss sg13_hv_nmos ad=1.125p pd=5u as=1.125p ps=5u w=9u l=7u
X160 avdd en enb avdd sg13_hv_pmos ad=1.125p pd=5u as=1.125p ps=5u w=9u l=3u
X161 bna enb avss avss sg13_hv_nmos ad=1.125p pd=5u as=1.125p ps=5u w=9u l=3u
X162 a_14300_6600# bna bpb avss sg13_hv_nmos ad=1.125p pd=5u as=1.125p ps=5u w=9u l=7u
X163 a_20100_5400# bnb bna_ avss sg13_hv_nmos ad=1.125p pd=5u as=1.125p ps=5u w=9u l=1u
X164 xn bna a_25500_5400# avss sg13_hv_nmos ad=1.125p pd=5u as=1.125p ps=5u w=9u l=7u
X165 bpa_l bpb bpb avdd sg13_hv_pmos ad=1.125p pd=5u as=1.125p ps=5u w=9u l=1u
X166 bpb bpb bpa_l avdd sg13_hv_pmos ad=1.125p pd=5u as=1.125p ps=5u w=9u l=1u
X167 bpa bna a_9500_5400# avss sg13_hv_nmos ad=1.125p pd=5u as=1.125p ps=5u w=9u l=7u
X168 bpa_r bpb bpb avdd sg13_hv_pmos ad=1.125p pd=5u as=1.125p ps=5u w=9u l=1u
X169 a_52500_6600# bnb zn_p avss sg13_hv_nmos ad=1.125p pd=5u as=1.125p ps=5u w=9u l=1u
X170 yn_p in_m xp avdd sg13_hv_pmos ad=1.125p pd=5u as=1.125p ps=5u w=9u l=1u
X171 bpb bpb bpa_r avdd sg13_hv_pmos ad=1.125p pd=5u as=1.125p ps=5u w=9u l=1u
X172 yp_m zp_m avdd avdd sg13_hv_pmos ad=1.125p pd=5u as=1.125p ps=5u w=9u l=7u
X173 zp_m zp_m yp_p avdd sg13_hv_pmos ad=1.125p pd=5u as=1.125p ps=5u w=9u l=1u
X174 yp_m zp_m zp_p avdd sg13_hv_pmos ad=1.125p pd=5u as=1.125p ps=5u w=9u l=1u
X175 zp_p zp_m yp_m avdd sg13_hv_pmos ad=1.125p pd=5u as=1.125p ps=5u w=9u l=1u
X176 a_20500_6600# bnb bnb avss sg13_hv_nmos ad=1.125p pd=5u as=1.125p ps=5u w=9u l=1u
X177 zn_m zn_m a_44900_5400# avss sg13_hv_nmos ad=1.125p pd=5u as=1.125p ps=5u w=9u l=1u
X178 avdd bpa bpa avdd sg13_hv_pmos ad=1.125p pd=5u as=1.125p ps=5u w=9u l=7u
X179 avdd zp_m yp_m avdd sg13_hv_pmos ad=1.125p pd=5u as=1.125p ps=5u w=9u l=7u
X180 a_16500_5400# bna_ a_16300_5400# avss sg13_hv_nmos ad=1.125p pd=5u as=1.125p ps=5u w=9u l=1u
X181 yp_p in_m a_28900_5400# avss sg13_hv_nmos ad=1.125p pd=5u as=1.125p ps=5u w=9u l=1u
X182 bpb bpb bpa_l avdd sg13_hv_pmos ad=1.125p pd=5u as=1.125p ps=5u w=9u l=1u
X183 bpa_l bpb bpb avdd sg13_hv_pmos ad=1.125p pd=5u as=1.125p ps=5u w=9u l=1u
X184 yn_p zn_m a_45300_6600# avss sg13_hv_nmos ad=1.125p pd=5u as=1.125p ps=5u w=9u l=1u
X185 bpb bpb bpa_r avdd sg13_hv_pmos ad=1.125p pd=5u as=1.125p ps=5u w=9u l=1u
X186 avss zn_p a_56500_5400# avss sg13_hv_nmos ad=1.125p pd=5u as=1.125p ps=5u w=9u l=1u
X187 yn_m zn_m a_50900_5400# avss sg13_hv_nmos ad=1.125p pd=5u as=1.125p ps=5u w=9u l=1u
X188 xp in_m yn_p avdd sg13_hv_pmos ad=1.125p pd=5u as=1.125p ps=5u w=9u l=1u
X189 xn in_m a_29300_6600# avss sg13_hv_nmos ad=1.125p pd=5u as=1.125p ps=5u w=9u l=1u
X190 bna_ bnb a_18100_6600# avss sg13_hv_nmos ad=1.125p pd=5u as=1.125p ps=5u w=9u l=1u
X191 a_23900_6600# bna_ a_23700_6600# avss sg13_hv_nmos ad=1.125p pd=5u as=1.125p ps=5u w=9u l=1u
X192 a_39100_5400# bnb a_41300_5400# avss sg13_hv_nmos ad=1.125p pd=5u as=1.125p ps=5u w=9u l=1u
X193 yp_p zp_m zp_m avdd sg13_hv_pmos ad=1.125p pd=5u as=1.125p ps=5u w=9u l=1u
X194 zn_p bpb zp_p avdd sg13_hv_pmos ad=1.125p pd=5u as=1.125p ps=5u w=9u l=1u
X195 zp_p zp_m yp_m avdd sg13_hv_pmos ad=1.125p pd=5u as=1.125p ps=5u w=9u l=1u
X196 bna_ bnb a_19700_5400# avss sg13_hv_nmos ad=1.125p pd=5u as=1.125p ps=5u w=9u l=1u
X197 zn_p zn_m a_51300_6600# avss sg13_hv_nmos ad=1.125p pd=5u as=1.125p ps=5u w=9u l=1u
X198 yp_m zp_m avdd avdd sg13_hv_pmos ad=1.125p pd=5u as=1.125p ps=5u w=9u l=7u
X199 out zp_p avdd avdd sg13_hv_pmos ad=1.125p pd=5u as=1.125p ps=5u w=9u l=1u
X200 bpa bpa avdd avdd sg13_hv_pmos ad=1.125p pd=5u as=1.125p ps=5u w=9u l=7u
X201 bpa_l bpa_l a_12500_1800# avdd sg13_hv_pmos ad=1.125p pd=5u as=1.125p ps=5u w=9u l=1u
X202 a_43900_6600# zn_m avss avss sg13_hv_nmos ad=1.125p pd=5u as=1.125p ps=5u w=9u l=7u
X203 a_49500_6600# zn_m avss avss sg13_hv_nmos ad=1.125p pd=5u as=1.125p ps=5u w=9u l=7u
X204 xp bpa avdd avdd sg13_hv_pmos ad=1.125p pd=5u as=1.125p ps=5u w=9u l=7u
X205 yn_m zn_m a_31900_6600# avss sg13_hv_nmos ad=1.125p pd=5u as=1.125p ps=5u w=9u l=7u
X206 a_38300_6600# bna avss avss sg13_hv_nmos ad=1.125p pd=5u as=1.125p ps=5u w=9u l=7u
X207 bpa_r bpb bpb avdd sg13_hv_pmos ad=1.125p pd=5u as=1.125p ps=5u w=9u l=1u
X208 yn_p in_m xp avdd sg13_hv_pmos ad=1.125p pd=5u as=1.125p ps=5u w=9u l=1u
X209 a_44900_5400# zn_m yn_p avss sg13_hv_nmos ad=1.125p pd=5u as=1.125p ps=5u w=9u l=1u
X210 avss zn_m a_33500_5400# avss sg13_hv_nmos ad=1.125p pd=5u as=1.125p ps=5u w=9u l=7u
X211 a_39300_5400# bnb a_39100_5400# avss sg13_hv_nmos ad=1.125p pd=5u as=1.125p ps=5u w=9u l=1u
X212 a_15500_5400# bna_ a_15300_5400# avss sg13_hv_nmos ad=1.125p pd=5u as=1.125p ps=5u w=9u l=1u
X213 a_28100_5400# in_m xn avss sg13_hv_nmos ad=1.125p pd=5u as=1.125p ps=5u w=9u l=1u
X214 yp_p zp_m zp_m avdd sg13_hv_pmos ad=1.125p pd=5u as=1.125p ps=5u w=9u l=1u
X215 zp_p bpb zn_p avdd sg13_hv_pmos ad=1.125p pd=5u as=1.125p ps=5u w=9u l=1u
X216 a_21100_600# bpa_r a_20900_600# avdd sg13_hv_pmos ad=1.125p pd=5u as=1.125p ps=5u w=9u l=1u
X217 avss en enb avss sg13_hv_nmos ad=1.125p pd=5u as=1.125p ps=5u w=9u l=3u
X218 avdd zp_p out avdd sg13_hv_pmos ad=1.125p pd=5u as=1.125p ps=5u w=9u l=1u
X219 a_28500_6600# in_m yp_p avss sg13_hv_nmos ad=1.125p pd=5u as=1.125p ps=5u w=9u l=1u
X220 a_40500_5400# bnb zp_m avss sg13_hv_nmos ad=1.125p pd=5u as=1.125p ps=5u w=9u l=1u
X221 bpb bpb bpa_l avdd sg13_hv_pmos ad=1.125p pd=5u as=1.125p ps=5u w=9u l=1u
X222 a_17300_6600# bnb bnb avss sg13_hv_nmos ad=1.125p pd=5u as=1.125p ps=5u w=9u l=1u
X223 a_22900_6600# bnb bnb avss sg13_hv_nmos ad=1.125p pd=5u as=1.125p ps=5u w=9u l=1u
X224 bna en ib avss sg13_hv_nmos ad=1.125p pd=5u as=1.125p ps=5u w=9u l=3u
X225 avdd bpa xp avdd sg13_hv_pmos ad=1.125p pd=5u as=1.125p ps=5u w=9u l=7u
X226 a_18900_5400# bnb bnb avss sg13_hv_nmos ad=1.125p pd=5u as=1.125p ps=5u w=9u l=1u
X227 a_24500_5400# bna_ a_24300_5400# avss sg13_hv_nmos ad=1.125p pd=5u as=1.125p ps=5u w=9u l=1u
X228 a_50500_6600# zn_m yn_m avss sg13_hv_nmos ad=1.125p pd=5u as=1.125p ps=5u w=9u l=1u
X229 zp_m zp_m yp_p avdd sg13_hv_pmos ad=1.125p pd=5u as=1.125p ps=5u w=9u l=1u
X230 a_16100_600# bpa_l bpa_l avdd sg13_hv_pmos ad=1.125p pd=5u as=1.125p ps=5u w=9u l=1u
X231 avss zn_p a_58900_5400# avss sg13_hv_nmos ad=1.125p pd=5u as=1.125p ps=5u w=9u l=1u
X232 a_21300_600# bpa_r a_21100_600# avdd sg13_hv_pmos ad=1.125p pd=5u as=1.125p ps=5u w=9u l=1u
X233 zp_m zp_m yp_p avdd sg13_hv_pmos ad=1.125p pd=5u as=1.125p ps=5u w=9u l=1u
X234 yp_m zp_m avdd avdd sg13_hv_pmos ad=1.125p pd=5u as=1.125p ps=5u w=9u l=7u
X235 zn_m bpb a_46700_600# avdd sg13_hv_pmos ad=1.125p pd=5u as=1.125p ps=5u w=9u l=1u
X236 xn in_p a_26900_5400# avss sg13_hv_nmos ad=1.125p pd=5u as=1.125p ps=5u w=9u l=1u
X237 out zp_p avdd avdd sg13_hv_pmos ad=1.125p pd=5u as=1.125p ps=5u w=9u l=1u
X238 zn_p zn_m a_53700_6600# avss sg13_hv_nmos ad=1.125p pd=5u as=1.125p ps=5u w=9u l=1u
X239 xp in_m yn_p avdd sg13_hv_pmos ad=1.125p pd=5u as=1.125p ps=5u w=9u l=1u
X240 a_16300_600# bpa_l a_16100_600# avdd sg13_hv_pmos ad=1.125p pd=5u as=1.125p ps=5u w=9u l=1u
X241 yp_m in_p a_27300_6600# avss sg13_hv_nmos ad=1.125p pd=5u as=1.125p ps=5u w=9u l=1u
X242 a_16300_6600# bna_ a_16100_6600# avss sg13_hv_nmos ad=1.125p pd=5u as=1.125p ps=5u w=9u l=1u
X243 bnb bnb a_21700_6600# avss sg13_hv_nmos ad=1.125p pd=5u as=1.125p ps=5u w=9u l=1u
X244 avdd bpa_r a_21300_600# avdd sg13_hv_pmos ad=1.125p pd=5u as=1.125p ps=5u w=9u l=1u
X245 yp_p zp_m zp_m avdd sg13_hv_pmos ad=1.125p pd=5u as=1.125p ps=5u w=9u l=1u
X246 zn_m bpb a_43900_600# avdd sg13_hv_pmos ad=1.125p pd=5u as=1.125p ps=5u w=9u l=1u
X247 bnb bnb a_17700_5400# avss sg13_hv_nmos ad=1.125p pd=5u as=1.125p ps=5u w=9u l=1u
X248 a_23500_5400# bna_ a_23300_5400# avss sg13_hv_nmos ad=1.125p pd=5u as=1.125p ps=5u w=9u l=1u
X249 yp_m zp_m zp_p avdd sg13_hv_pmos ad=1.125p pd=5u as=1.125p ps=5u w=9u l=1u
X250 avdd zp_m yp_p avdd sg13_hv_pmos ad=1.125p pd=5u as=1.125p ps=5u w=9u l=7u
X251 a_56300_600# zp_p out avdd sg13_hv_pmos ad=1.125p pd=5u as=1.125p ps=5u w=9u l=1u
X252 avdd tihi tihi avdd sg13_hv_pmos ad=1.125p pd=5u as=1.125p ps=5u w=9u l=19u
X253 a_43900_600# bpb zn_m avdd sg13_hv_pmos ad=1.125p pd=5u as=1.125p ps=5u w=9u l=1u
X254 a_58100_5400# zn_p out avss sg13_hv_nmos ad=1.125p pd=5u as=1.125p ps=5u w=9u l=1u
X255 a_41300_6600# bnb zp_m avss sg13_hv_nmos ad=1.125p pd=5u as=1.125p ps=5u w=9u l=1u
X256 a_46900_6600# zn_m zn_m avss sg13_hv_nmos ad=1.125p pd=5u as=1.125p ps=5u w=9u l=1u
X257 avdd bpa bpa avdd sg13_hv_pmos ad=1.125p pd=5u as=1.125p ps=5u w=9u l=7u
X258 a_16500_600# bpa_l a_16300_600# avdd sg13_hv_pmos ad=1.125p pd=5u as=1.125p ps=5u w=9u l=1u
X259 avdd bpa xp avdd sg13_hv_pmos ad=1.125p pd=5u as=1.125p ps=5u w=9u l=7u
X260 a_19700_6600# bnb bnb avss sg13_hv_nmos ad=1.125p pd=5u as=1.125p ps=5u w=9u l=1u
X261 bpa_r bpb bpb avdd sg13_hv_pmos ad=1.125p pd=5u as=1.125p ps=5u w=9u l=1u
X262 yp_p zp_m zp_m avdd sg13_hv_pmos ad=1.125p pd=5u as=1.125p ps=5u w=9u l=1u
X263 a_43900_600# bpb zn_m avdd sg13_hv_pmos ad=1.125p pd=5u as=1.125p ps=5u w=9u l=1u
X264 a_52900_6600# bnb zp_p avss sg13_hv_nmos ad=1.125p pd=5u as=1.125p ps=5u w=9u l=1u
X265 a_58500_6600# zn_p avss avss sg13_hv_nmos ad=1.125p pd=5u as=1.125p ps=5u w=9u l=1u
X266 zp_p zp_m yp_m avdd sg13_hv_pmos ad=1.125p pd=5u as=1.125p ps=5u w=9u l=1u
X267 out zp_p a_56300_600# avdd sg13_hv_pmos ad=1.125p pd=5u as=1.125p ps=5u w=9u l=1u
X268 a_55100_5400# zn_m yn_m avss sg13_hv_nmos ad=1.125p pd=5u as=1.125p ps=5u w=9u l=7u
X269 a_26500_6600# in_p xn avss sg13_hv_nmos ad=1.125p pd=5u as=1.125p ps=5u w=9u l=1u
X270 avdd bpa a_43900_600# avdd sg13_hv_pmos ad=1.125p pd=5u as=1.125p ps=5u w=9u l=7u
X271 a_58700_600# zp_p out avdd sg13_hv_pmos ad=1.125p pd=5u as=1.125p ps=5u w=9u l=1u
X272 a_15300_6600# bna_ avss avss sg13_hv_nmos ad=1.125p pd=5u as=1.125p ps=5u w=9u l=1u
X273 a_20900_6600# bnb bna_ avss sg13_hv_nmos ad=1.125p pd=5u as=1.125p ps=5u w=9u l=1u
X274 bpb bpb bpa_l avdd sg13_hv_pmos ad=1.125p pd=5u as=1.125p ps=5u w=9u l=1u
X275 a_16900_5400# bnb bna_ avss sg13_hv_nmos ad=1.125p pd=5u as=1.125p ps=5u w=9u l=1u
X276 a_22500_5400# bnb bna_ avss sg13_hv_nmos ad=1.125p pd=5u as=1.125p ps=5u w=9u l=1u
X277 ib en bna avss sg13_hv_nmos ad=1.125p pd=5u as=1.125p ps=5u w=9u l=3u
X278 avss bna a_11100_5400# avss sg13_hv_nmos ad=1.125p pd=5u as=1.125p ps=5u w=9u l=7u
X279 bpb bpb bpa_r avdd sg13_hv_pmos ad=1.125p pd=5u as=1.125p ps=5u w=9u l=1u
X280 zp_m zp_m yp_p avdd sg13_hv_pmos ad=1.125p pd=5u as=1.125p ps=5u w=9u l=1u
X281 zn_m bpb a_43900_600# avdd sg13_hv_pmos ad=1.125p pd=5u as=1.125p ps=5u w=9u l=1u
X282 out zn_p a_56900_5400# avss sg13_hv_nmos ad=1.125p pd=5u as=1.125p ps=5u w=9u l=1u
X283 zp_m bnb a_40100_6600# avss sg13_hv_nmos ad=1.125p pd=5u as=1.125p ps=5u w=9u l=1u
X284 zn_m zn_m a_45700_6600# avss sg13_hv_nmos ad=1.125p pd=5u as=1.125p ps=5u w=9u l=1u
X285 yp_m zp_m zp_p avdd sg13_hv_pmos ad=1.125p pd=5u as=1.125p ps=5u w=9u l=1u
X286 bnb bpa avdd avdd sg13_hv_pmos ad=1.125p pd=5u as=1.125p ps=5u w=9u l=7u
X287 zp_p zp_m yp_m avdd sg13_hv_pmos ad=1.125p pd=5u as=1.125p ps=5u w=9u l=1u
X288 a_24300_6600# bna_ a_24100_6600# avss sg13_hv_nmos ad=1.125p pd=5u as=1.125p ps=5u w=9u l=1u
X289 bnb bnb a_18500_6600# avss sg13_hv_nmos ad=1.125p pd=5u as=1.125p ps=5u w=9u l=1u
X290 out zp_p a_58700_600# avdd sg13_hv_pmos ad=1.125p pd=5u as=1.125p ps=5u w=9u l=1u
X291 zn_m bpb a_46700_600# avdd sg13_hv_pmos ad=1.125p pd=5u as=1.125p ps=5u w=9u l=1u
X292 bpa_l bpb bpb avdd sg13_hv_pmos ad=1.125p pd=5u as=1.125p ps=5u w=9u l=1u
X293 zp_p bnb a_51700_6600# avss sg13_hv_nmos ad=1.125p pd=5u as=1.125p ps=5u w=9u l=1u
X294 avss zn_p a_57300_6600# avss sg13_hv_nmos ad=1.125p pd=5u as=1.125p ps=5u w=9u l=1u
X295 yp_p zp_m zp_m avdd sg13_hv_pmos ad=1.125p pd=5u as=1.125p ps=5u w=9u l=1u
X296 avdd bpa_l a_16500_1800# avdd sg13_hv_pmos ad=1.125p pd=5u as=1.125p ps=5u w=9u l=1u
X297 yn_m zn_m a_53300_5400# avss sg13_hv_nmos ad=1.125p pd=5u as=1.125p ps=5u w=9u l=1u
X298 yn_p in_m xp avdd sg13_hv_pmos ad=1.125p pd=5u as=1.125p ps=5u w=9u l=1u
X299 a_39700_5400# bnb zp_m avss sg13_hv_nmos ad=1.125p pd=5u as=1.125p ps=5u w=9u l=1u
X300 yp_p zp_m avdd avdd sg13_hv_pmos ad=1.125p pd=5u as=1.125p ps=5u w=9u l=7u
X301 zn_p bpb zp_p avdd sg13_hv_pmos ad=1.125p pd=5u as=1.125p ps=5u w=9u l=1u
X302 avdd bpa bnb avdd sg13_hv_pmos ad=1.125p pd=5u as=1.125p ps=5u w=9u l=7u
X303 a_15900_5400# bna_ a_15700_5400# avss sg13_hv_nmos ad=1.125p pd=5u as=1.125p ps=5u w=9u l=1u
X304 bna_ bnb a_21300_5400# avss sg13_hv_nmos ad=1.125p pd=5u as=1.125p ps=5u w=9u l=1u
X305 bpa bpa avdd avdd sg13_hv_pmos ad=1.125p pd=5u as=1.125p ps=5u w=9u l=7u
X306 a_46700_600# bpb zn_m avdd sg13_hv_pmos ad=1.125p pd=5u as=1.125p ps=5u w=9u l=1u
X307 avdd zp_p out avdd sg13_hv_pmos ad=1.125p pd=5u as=1.125p ps=5u w=9u l=1u
X308 a_4700_5400# bna avss avss sg13_hv_nmos ad=1.125p pd=5u as=1.125p ps=5u w=9u l=7u
X309 xp bpa avdd avdd sg13_hv_pmos ad=1.125p pd=5u as=1.125p ps=5u w=9u l=7u
X310 a_56100_5400# zn_p avss avss sg13_hv_nmos ad=1.125p pd=5u as=1.125p ps=5u w=9u l=1u
X311 a_35100_6600# zn_m avss avss sg13_hv_nmos ad=1.125p pd=5u as=1.125p ps=5u w=9u l=7u
X312 a_23300_6600# bna_ bna_ avss sg13_hv_nmos ad=1.125p pd=5u as=1.125p ps=5u w=9u l=1u
X313 a_28900_6600# in_m xn avss sg13_hv_nmos ad=1.125p pd=5u as=1.125p ps=5u w=9u l=1u
X314 a_40900_5400# bnb a_39100_5400# avss sg13_hv_nmos ad=1.125p pd=5u as=1.125p ps=5u w=9u l=1u
X315 a_16900_1800# bpa_r avdd avdd sg13_hv_pmos ad=1.125p pd=5u as=1.125p ps=5u w=9u l=1u
X316 a_46500_5400# zn_m yn_p avss sg13_hv_nmos ad=1.125p pd=5u as=1.125p ps=5u w=9u l=1u
X317 a_12700_6600# bna avss avss sg13_hv_nmos ad=1.125p pd=5u as=1.125p ps=5u w=9u l=7u
X318 a_17700_6600# bnb bna_ avss sg13_hv_nmos ad=1.125p pd=5u as=1.125p ps=5u w=9u l=1u
X319 yn_p zn_m a_35100_5400# avss sg13_hv_nmos ad=1.125p pd=5u as=1.125p ps=5u w=9u l=7u
X320 xp in_m yn_p avdd sg13_hv_pmos ad=1.125p pd=5u as=1.125p ps=5u w=9u l=1u
X321 bpa_r bpb bpb avdd sg13_hv_pmos ad=1.125p pd=5u as=1.125p ps=5u w=9u l=1u
X322 yp_p zp_m avdd avdd sg13_hv_pmos ad=1.125p pd=5u as=1.125p ps=5u w=9u l=7u
X323 a_14300_5400# bna bpb avss sg13_hv_nmos ad=1.125p pd=5u as=1.125p ps=5u w=9u l=7u
X324 a_19300_5400# bnb bna_ avss sg13_hv_nmos ad=1.125p pd=5u as=1.125p ps=5u w=9u l=1u
X325 a_25500_5400# bna avss avss sg13_hv_nmos ad=1.125p pd=5u as=1.125p ps=5u w=9u l=7u
X326 a_50900_6600# zn_m zn_p avss sg13_hv_nmos ad=1.125p pd=5u as=1.125p ps=5u w=9u l=1u
X327 a_56500_6600# zn_p out avss sg13_hv_nmos ad=1.125p pd=5u as=1.125p ps=5u w=9u l=1u
X328 bna enb avss avss sg13_hv_nmos ad=1.125p pd=5u as=1.125p ps=5u w=9u l=3u
X329 avdd zp_m yp_m avdd sg13_hv_pmos ad=1.125p pd=5u as=1.125p ps=5u w=9u l=7u
X330 bpb bpb bpa_r avdd sg13_hv_pmos ad=1.125p pd=5u as=1.125p ps=5u w=9u l=1u
X331 out zp_p avdd avdd sg13_hv_pmos ad=1.125p pd=5u as=1.125p ps=5u w=9u l=1u
X332 a_52500_5400# bnb zn_p avss sg13_hv_nmos ad=1.125p pd=5u as=1.125p ps=5u w=9u l=1u
X333 avdd zp_p out avdd sg13_hv_pmos ad=1.125p pd=5u as=1.125p ps=5u w=9u l=1u
X334 avss enb bna avss sg13_hv_nmos ad=1.125p pd=5u as=1.125p ps=5u w=9u l=3u
X335 avdd zp_m yp_p avdd sg13_hv_pmos ad=1.125p pd=5u as=1.125p ps=5u w=9u l=7u
X336 bpb bpb bpa_l avdd sg13_hv_pmos ad=1.125p pd=5u as=1.125p ps=5u w=9u l=1u
X337 a_20500_5400# bnb bnb avss sg13_hv_nmos ad=1.125p pd=5u as=1.125p ps=5u w=9u l=1u
X338 xp in_p yn_m avdd sg13_hv_pmos ad=1.125p pd=5u as=1.125p ps=5u w=9u l=1u
X339 bpb bpb bpa_r avdd sg13_hv_pmos ad=1.125p pd=5u as=1.125p ps=5u w=9u l=1u
X340 yn_m zn_m a_54100_6600# avss sg13_hv_nmos ad=1.125p pd=5u as=1.125p ps=5u w=9u l=1u
X341 bpa_l bpb bpb avdd sg13_hv_pmos ad=1.125p pd=5u as=1.125p ps=5u w=9u l=1u
X342 bpa_r bpb bpb avdd sg13_hv_pmos ad=1.125p pd=5u as=1.125p ps=5u w=9u l=1u
X343 zp_p bpb zn_p avdd sg13_hv_pmos ad=1.125p pd=5u as=1.125p ps=5u w=9u l=1u
X344 bna_ bnb a_22100_6600# avss sg13_hv_nmos ad=1.125p pd=5u as=1.125p ps=5u w=9u l=1u
X345 xn in_p a_27700_6600# avss sg13_hv_nmos ad=1.125p pd=5u as=1.125p ps=5u w=9u l=1u
X346 yn_p zn_m a_45300_5400# avss sg13_hv_nmos ad=1.125p pd=5u as=1.125p ps=5u w=9u l=1u
X347 bna_ bna_ a_16500_6600# avss sg13_hv_nmos ad=1.125p pd=5u as=1.125p ps=5u w=9u l=1u
X348 zp_p en avdd avdd sg13_hv_pmos ad=1.125p pd=5u as=1.125p ps=5u w=9u l=3u
X349 xn in_m a_29300_5400# avss sg13_hv_nmos ad=1.125p pd=5u as=1.125p ps=5u w=9u l=1u
X350 avdd bpa a_46700_600# avdd sg13_hv_pmos ad=1.125p pd=5u as=1.125p ps=5u w=9u l=7u
X351 bna_ bnb a_18100_5400# avss sg13_hv_nmos ad=1.125p pd=5u as=1.125p ps=5u w=9u l=1u
X352 a_23900_5400# bna_ a_23700_5400# avss sg13_hv_nmos ad=1.125p pd=5u as=1.125p ps=5u w=9u l=1u
X353 yp_m zp_m zp_p avdd sg13_hv_pmos ad=1.125p pd=5u as=1.125p ps=5u w=9u l=1u
X354 bpa_l bpb bpb avdd sg13_hv_pmos ad=1.125p pd=5u as=1.125p ps=5u w=9u l=1u
X355 yn_m in_p xp avdd sg13_hv_pmos ad=1.125p pd=5u as=1.125p ps=5u w=9u l=1u
X356 avdd en enb avdd sg13_hv_pmos ad=1.125p pd=5u as=1.125p ps=5u w=9u l=3u
X357 bpa_r bpb bpb avdd sg13_hv_pmos ad=1.125p pd=5u as=1.125p ps=5u w=9u l=1u
X358 zn_p zn_m a_51300_5400# avss sg13_hv_nmos ad=1.125p pd=5u as=1.125p ps=5u w=9u l=1u
X359 a_47900_6600# zn_m yn_p avss sg13_hv_nmos ad=1.125p pd=5u as=1.125p ps=5u w=9u l=7u
X360 a_36700_6600# zn_m yn_p avss sg13_hv_nmos ad=1.125p pd=5u as=1.125p ps=5u w=9u l=7u
X361 a_42300_6600# bna a_39100_5400# avss sg13_hv_nmos ad=1.125p pd=5u as=1.125p ps=5u w=9u l=7u
X362 bpb bpb bpa_l avdd sg13_hv_pmos ad=1.125p pd=5u as=1.125p ps=5u w=9u l=1u
X363 yn_p in_m xp avdd sg13_hv_pmos ad=1.125p pd=5u as=1.125p ps=5u w=9u l=1u
X364 a_49500_5400# zn_m avss avss sg13_hv_nmos ad=1.125p pd=5u as=1.125p ps=5u w=9u l=7u
X365 a_38300_5400# bna avss avss sg13_hv_nmos ad=1.125p pd=5u as=1.125p ps=5u w=9u l=7u
X366 a_43900_5400# zn_m avss avss sg13_hv_nmos ad=1.125p pd=5u as=1.125p ps=5u w=9u l=7u
X367 bpb bpb bpa_r avdd sg13_hv_pmos ad=1.125p pd=5u as=1.125p ps=5u w=9u l=1u
X368 zn_p bpb zp_p avdd sg13_hv_pmos ad=1.125p pd=5u as=1.125p ps=5u w=9u l=1u
X369 yn_m zn_m a_31900_5400# avss sg13_hv_nmos ad=1.125p pd=5u as=1.125p ps=5u w=9u l=7u
X370 zp_p zp_m yp_m avdd sg13_hv_pmos ad=1.125p pd=5u as=1.125p ps=5u w=9u l=1u
X371 a_53300_6600# zn_m zn_p avss sg13_hv_nmos ad=1.125p pd=5u as=1.125p ps=5u w=9u l=1u
X372 a_58900_6600# zn_p out avss sg13_hv_nmos ad=1.125p pd=5u as=1.125p ps=5u w=9u l=1u
X373 avdd zp_m yp_m avdd sg13_hv_pmos ad=1.125p pd=5u as=1.125p ps=5u w=9u l=7u
X374 bpb bpb bpa_l avdd sg13_hv_pmos ad=1.125p pd=5u as=1.125p ps=5u w=9u l=1u
X375 a_21300_6600# bnb bnb avss sg13_hv_nmos ad=1.125p pd=5u as=1.125p ps=5u w=9u l=1u
X376 a_26900_6600# in_p yp_m avss sg13_hv_nmos ad=1.125p pd=5u as=1.125p ps=5u w=9u l=1u
X377 a_15700_6600# bna_ a_15500_6600# avss sg13_hv_nmos ad=1.125p pd=5u as=1.125p ps=5u w=9u l=1u
X378 bpa_l bpb bpb avdd sg13_hv_pmos ad=1.125p pd=5u as=1.125p ps=5u w=9u l=1u
X379 xp in_m yn_p avdd sg13_hv_pmos ad=1.125p pd=5u as=1.125p ps=5u w=9u l=1u
X380 a_22900_5400# bnb bnb avss sg13_hv_nmos ad=1.125p pd=5u as=1.125p ps=5u w=9u l=1u
X381 a_28500_5400# in_m yp_p avss sg13_hv_nmos ad=1.125p pd=5u as=1.125p ps=5u w=9u l=1u
X382 bpb bpb bpa_r avdd sg13_hv_pmos ad=1.125p pd=5u as=1.125p ps=5u w=9u l=1u
X383 a_17300_5400# bnb bnb avss sg13_hv_nmos ad=1.125p pd=5u as=1.125p ps=5u w=9u l=1u
X384 zp_p bpb zn_p avdd sg13_hv_pmos ad=1.125p pd=5u as=1.125p ps=5u w=9u l=1u
X385 bna en ib avss sg13_hv_nmos ad=1.125p pd=5u as=1.125p ps=5u w=9u l=3u
X386 a_43900_600# bpa avdd avdd sg13_hv_pmos ad=1.125p pd=5u as=1.125p ps=5u w=9u l=7u
X387 zn_p bpb zp_p avdd sg13_hv_pmos ad=1.125p pd=5u as=1.125p ps=5u w=9u l=1u
X388 a_50500_5400# zn_m yn_m avss sg13_hv_nmos ad=1.125p pd=5u as=1.125p ps=5u w=9u l=1u
X389 yn_p zn_m a_46100_6600# avss sg13_hv_nmos ad=1.125p pd=5u as=1.125p ps=5u w=9u l=1u
X390 a_39100_5400# bnb a_40500_6600# avss sg13_hv_nmos ad=1.125p pd=5u as=1.125p ps=5u w=9u l=1u
X391 avdd zp_m yp_m avdd sg13_hv_pmos ad=1.125p pd=5u as=1.125p ps=5u w=9u l=7u
X392 out zp_p avdd avdd sg13_hv_pmos ad=1.125p pd=5u as=1.125p ps=5u w=9u l=1u
X393 bpa bpa avdd avdd sg13_hv_pmos ad=1.125p pd=5u as=1.125p ps=5u w=9u l=7u
X394 a_7100_6600# bna bna avss sg13_hv_nmos ad=1.125p pd=5u as=1.125p ps=5u w=9u l=7u
X395 bna_ bnb a_18900_6600# avss sg13_hv_nmos ad=1.125p pd=5u as=1.125p ps=5u w=9u l=1u
X396 avss bna_ a_24500_6600# avss sg13_hv_nmos ad=1.125p pd=5u as=1.125p ps=5u w=9u l=1u
X397 bpa_l bpa_l a_12500_600# avdd sg13_hv_pmos ad=1.125p pd=5u as=1.125p ps=5u w=9u l=1u
X398 xp in_p yn_m avdd sg13_hv_pmos ad=1.125p pd=5u as=1.125p ps=5u w=9u l=1u
X399 bpa_r bpb bpb avdd sg13_hv_pmos ad=1.125p pd=5u as=1.125p ps=5u w=9u l=1u
X400 zn_p bnb a_52100_6600# avss sg13_hv_nmos ad=1.125p pd=5u as=1.125p ps=5u w=9u l=1u
X401 out zn_p a_57700_6600# avss sg13_hv_nmos ad=1.125p pd=5u as=1.125p ps=5u w=9u l=1u
X402 zp_p bpb zn_p avdd sg13_hv_pmos ad=1.125p pd=5u as=1.125p ps=5u w=9u l=1u
X403 bpa_r bpb bpb avdd sg13_hv_pmos ad=1.125p pd=5u as=1.125p ps=5u w=9u l=1u
X404 zn_p zn_m a_53700_5400# avss sg13_hv_nmos ad=1.125p pd=5u as=1.125p ps=5u w=9u l=1u
X405 yn_p zn_m a_43900_6600# avss sg13_hv_nmos ad=1.125p pd=5u as=1.125p ps=5u w=9u l=7u
X406 yn_m zn_m a_49500_6600# avss sg13_hv_nmos ad=1.125p pd=5u as=1.125p ps=5u w=9u l=7u
X407 bnb bnb a_20100_6600# avss sg13_hv_nmos ad=1.125p pd=5u as=1.125p ps=5u w=9u l=1u
X408 a_57900_600# zp_p out avdd sg13_hv_pmos ad=1.125p pd=5u as=1.125p ps=5u w=9u l=1u
X409 bnb bnb a_21700_5400# avss sg13_hv_nmos ad=1.125p pd=5u as=1.125p ps=5u w=9u l=1u
X410 yp_m in_p a_27300_5400# avss sg13_hv_nmos ad=1.125p pd=5u as=1.125p ps=5u w=9u l=1u
X411 yp_p zp_m avdd avdd sg13_hv_pmos ad=1.125p pd=5u as=1.125p ps=5u w=9u l=7u
X412 a_16300_5400# bna_ a_16100_5400# avss sg13_hv_nmos ad=1.125p pd=5u as=1.125p ps=5u w=9u l=1u
X413 bpb bpb bpa_l avdd sg13_hv_pmos ad=1.125p pd=5u as=1.125p ps=5u w=9u l=1u
X414 yn_m in_p xp avdd sg13_hv_pmos ad=1.125p pd=5u as=1.125p ps=5u w=9u l=1u
X415 tihi tihi avdd avdd sg13_hv_pmos ad=1.125p pd=5u as=1.125p ps=5u w=9u l=19u
X416 zp_m zp_m yp_p avdd sg13_hv_pmos ad=1.125p pd=5u as=1.125p ps=5u w=9u l=1u
X417 a_45300_6600# zn_m zn_m avss sg13_hv_nmos ad=1.125p pd=5u as=1.125p ps=5u w=9u l=1u
X418 bpb bpb bpa_l avdd sg13_hv_pmos ad=1.125p pd=5u as=1.125p ps=5u w=9u l=1u
X419 a_20900_1800# bpa_r bpa_r avdd sg13_hv_pmos ad=1.125p pd=5u as=1.125p ps=5u w=9u l=1u
X420 a_46900_5400# zn_m zn_m avss sg13_hv_nmos ad=1.125p pd=5u as=1.125p ps=5u w=9u l=1u
X421 a_18100_6600# bnb bnb avss sg13_hv_nmos ad=1.125p pd=5u as=1.125p ps=5u w=9u l=1u
X422 a_23700_6600# bna_ a_23500_6600# avss sg13_hv_nmos ad=1.125p pd=5u as=1.125p ps=5u w=9u l=1u
X423 a_29300_6600# in_m yp_p avss sg13_hv_nmos ad=1.125p pd=5u as=1.125p ps=5u w=9u l=1u
X424 a_41300_5400# bnb zp_m avss sg13_hv_nmos ad=1.125p pd=5u as=1.125p ps=5u w=9u l=1u
X425 zp_m zp_m yp_p avdd sg13_hv_pmos ad=1.125p pd=5u as=1.125p ps=5u w=9u l=1u
X426 a_56900_6600# zn_p avss avss sg13_hv_nmos ad=1.125p pd=5u as=1.125p ps=5u w=9u l=1u
X427 a_19700_5400# bnb bnb avss sg13_hv_nmos ad=1.125p pd=5u as=1.125p ps=5u w=9u l=1u
X428 bna bna a_4700_6600# avss sg13_hv_nmos ad=1.125p pd=5u as=1.125p ps=5u w=9u l=7u
X429 a_51300_6600# zn_m yn_m avss sg13_hv_nmos ad=1.125p pd=5u as=1.125p ps=5u w=9u l=1u
X430 zn_m bpb a_46700_600# avdd sg13_hv_pmos ad=1.125p pd=5u as=1.125p ps=5u w=9u l=1u
X431 xp in_p yn_m avdd sg13_hv_pmos ad=1.125p pd=5u as=1.125p ps=5u w=9u l=1u
X432 a_58500_5400# zn_p avss avss sg13_hv_nmos ad=1.125p pd=5u as=1.125p ps=5u w=9u l=1u
X433 a_52900_5400# bnb zp_p avss sg13_hv_nmos ad=1.125p pd=5u as=1.125p ps=5u w=9u l=1u
X434 avss bna a_30300_6600# avss sg13_hv_nmos ad=1.125p pd=5u as=1.125p ps=5u w=9u l=7u
X435 bpa_l bpb bpb avdd sg13_hv_pmos ad=1.125p pd=5u as=1.125p ps=5u w=9u l=1u
X436 a_9500_6600# bna avss avss sg13_hv_nmos ad=1.125p pd=5u as=1.125p ps=5u w=9u l=7u
X437 avss bna a_14300_6600# avss sg13_hv_nmos ad=1.125p pd=5u as=1.125p ps=5u w=9u l=7u
X438 a_20900_5400# bnb bna_ avss sg13_hv_nmos ad=1.125p pd=5u as=1.125p ps=5u w=9u l=1u
X439 a_26500_5400# in_p xn avss sg13_hv_nmos ad=1.125p pd=5u as=1.125p ps=5u w=9u l=1u
X440 bpb bpb bpa_r avdd sg13_hv_pmos ad=1.125p pd=5u as=1.125p ps=5u w=9u l=1u
X441 a_15300_5400# bna_ avss avss sg13_hv_nmos ad=1.125p pd=5u as=1.125p ps=5u w=9u l=1u
X442 xp in_m yn_p avdd sg13_hv_pmos ad=1.125p pd=5u as=1.125p ps=5u w=9u l=1u
X443 bnb bpa avdd avdd sg13_hv_pmos ad=1.125p pd=5u as=1.125p ps=5u w=9u l=7u
X444 zn_p bpb zp_p avdd sg13_hv_pmos ad=1.125p pd=5u as=1.125p ps=5u w=9u l=1u
X445 yp_p zp_m zp_m avdd sg13_hv_pmos ad=1.125p pd=5u as=1.125p ps=5u w=9u l=1u
X446 zn_m bpb a_43900_600# avdd sg13_hv_pmos ad=1.125p pd=5u as=1.125p ps=5u w=9u l=1u
X447 out zp_p avdd avdd sg13_hv_pmos ad=1.125p pd=5u as=1.125p ps=5u w=9u l=1u
X448 zp_m bnb a_39300_6600# avss sg13_hv_nmos ad=1.125p pd=5u as=1.125p ps=5u w=9u l=1u
X449 zn_m zn_m a_45700_5400# avss sg13_hv_nmos ad=1.125p pd=5u as=1.125p ps=5u w=9u l=1u
X450 bnb bnb a_16900_6600# avss sg13_hv_nmos ad=1.125p pd=5u as=1.125p ps=5u w=9u l=1u
X451 bnb bnb a_22500_6600# avss sg13_hv_nmos ad=1.125p pd=5u as=1.125p ps=5u w=9u l=1u
X452 yp_p in_m a_28100_6600# avss sg13_hv_nmos ad=1.125p pd=5u as=1.125p ps=5u w=9u l=1u
X453 zp_m bnb a_40100_5400# avss sg13_hv_nmos ad=1.125p pd=5u as=1.125p ps=5u w=9u l=1u
X454 bpa_l bpb bpb avdd sg13_hv_pmos ad=1.125p pd=5u as=1.125p ps=5u w=9u l=1u
X455 a_24300_5400# bna_ a_24100_5400# avss sg13_hv_nmos ad=1.125p pd=5u as=1.125p ps=5u w=9u l=1u
X456 bnb bnb a_18500_5400# avss sg13_hv_nmos ad=1.125p pd=5u as=1.125p ps=5u w=9u l=1u
X457 bpa_r bpb bpb avdd sg13_hv_pmos ad=1.125p pd=5u as=1.125p ps=5u w=9u l=1u
X458 avdd bpa xp avdd sg13_hv_pmos ad=1.125p pd=5u as=1.125p ps=5u w=9u l=7u
X459 yp_p zp_m zp_m avdd sg13_hv_pmos ad=1.125p pd=5u as=1.125p ps=5u w=9u l=1u
X460 zp_p bpb zn_p avdd sg13_hv_pmos ad=1.125p pd=5u as=1.125p ps=5u w=9u l=1u
X461 avss zn_p a_57300_5400# avss sg13_hv_nmos ad=1.125p pd=5u as=1.125p ps=5u w=9u l=1u
X462 zp_p bnb a_51700_5400# avss sg13_hv_nmos ad=1.125p pd=5u as=1.125p ps=5u w=9u l=1u
X463 a_43900_600# bpb zn_m avdd sg13_hv_pmos ad=1.125p pd=5u as=1.125p ps=5u w=9u l=1u
X464 avdd zp_p out avdd sg13_hv_pmos ad=1.125p pd=5u as=1.125p ps=5u w=9u l=1u
X465 bpa en avdd avdd sg13_hv_pmos ad=1.125p pd=5u as=1.125p ps=5u w=9u l=3u
X466 a_46700_600# bpb zn_m avdd sg13_hv_pmos ad=1.125p pd=5u as=1.125p ps=5u w=9u l=1u
X467 bpb bpb bpa_l avdd sg13_hv_pmos ad=1.125p pd=5u as=1.125p ps=5u w=9u l=1u
X468 zn_p enb avss avss sg13_hv_nmos ad=1.125p pd=5u as=1.125p ps=5u w=9u l=3u
X469 a_53700_6600# zn_m yn_m avss sg13_hv_nmos ad=1.125p pd=5u as=1.125p ps=5u w=9u l=1u
X470 bpb bpb bpa_r avdd sg13_hv_pmos ad=1.125p pd=5u as=1.125p ps=5u w=9u l=1u
X471 zp_m zp_m yp_p avdd sg13_hv_pmos ad=1.125p pd=5u as=1.125p ps=5u w=9u l=1u
X472 a_33500_6600# zn_m yn_m avss sg13_hv_nmos ad=1.125p pd=5u as=1.125p ps=5u w=9u l=7u
X473 a_39100_5400# bna a_38300_6600# avss sg13_hv_nmos ad=1.125p pd=5u as=1.125p ps=5u w=9u l=7u
X474 a_16100_6600# bna_ a_15900_6600# avss sg13_hv_nmos ad=1.125p pd=5u as=1.125p ps=5u w=9u l=1u
X475 a_21700_6600# bnb bna_ avss sg13_hv_nmos ad=1.125p pd=5u as=1.125p ps=5u w=9u l=1u
X476 a_27300_6600# in_p xn avss sg13_hv_nmos ad=1.125p pd=5u as=1.125p ps=5u w=9u l=1u
X477 zn_m bpb a_43900_600# avdd sg13_hv_pmos ad=1.125p pd=5u as=1.125p ps=5u w=9u l=1u
X478 zp_p zp_m yp_m avdd sg13_hv_pmos ad=1.125p pd=5u as=1.125p ps=5u w=9u l=1u
X479 a_35100_5400# zn_m avss avss sg13_hv_nmos ad=1.125p pd=5u as=1.125p ps=5u w=9u l=7u
X480 bnb bpa avdd avdd sg13_hv_pmos ad=1.125p pd=5u as=1.125p ps=5u w=9u l=7u
X481 zp_m zp_m yp_p avdd sg13_hv_pmos ad=1.125p pd=5u as=1.125p ps=5u w=9u l=1u
X482 a_23300_5400# bna_ bna_ avss sg13_hv_nmos ad=1.125p pd=5u as=1.125p ps=5u w=9u l=1u
X483 a_28900_5400# in_m xn avss sg13_hv_nmos ad=1.125p pd=5u as=1.125p ps=5u w=9u l=1u
X484 a_12700_5400# bna avss avss sg13_hv_nmos ad=1.125p pd=5u as=1.125p ps=5u w=9u l=7u
X485 a_17700_5400# bnb bna_ avss sg13_hv_nmos ad=1.125p pd=5u as=1.125p ps=5u w=9u l=1u
X486 out zp_p avdd avdd sg13_hv_pmos ad=1.125p pd=5u as=1.125p ps=5u w=9u l=1u
X487 zn_m bpb a_46700_600# avdd sg13_hv_pmos ad=1.125p pd=5u as=1.125p ps=5u w=9u l=1u
X488 bpa_l bpb bpb avdd sg13_hv_pmos ad=1.125p pd=5u as=1.125p ps=5u w=9u l=1u
X489 a_56500_5400# zn_p out avss sg13_hv_nmos ad=1.125p pd=5u as=1.125p ps=5u w=9u l=1u
X490 a_50900_5400# zn_m zn_p avss sg13_hv_nmos ad=1.125p pd=5u as=1.125p ps=5u w=9u l=1u
X491 zp_m bnb a_40900_6600# avss sg13_hv_nmos ad=1.125p pd=5u as=1.125p ps=5u w=9u l=1u
X492 zn_m zn_m a_46500_6600# avss sg13_hv_nmos ad=1.125p pd=5u as=1.125p ps=5u w=9u l=1u
X493 yp_p zp_m zp_m avdd sg13_hv_pmos ad=1.125p pd=5u as=1.125p ps=5u w=9u l=1u
X494 avdd bpa_l a_16500_600# avdd sg13_hv_pmos ad=1.125p pd=5u as=1.125p ps=5u w=9u l=1u
X495 yp_m zp_m zp_p avdd sg13_hv_pmos ad=1.125p pd=5u as=1.125p ps=5u w=9u l=1u
X496 avss enb bna avss sg13_hv_nmos ad=1.125p pd=5u as=1.125p ps=5u w=9u l=3u
X497 avss zn_p a_58100_6600# avss sg13_hv_nmos ad=1.125p pd=5u as=1.125p ps=5u w=9u l=1u
X498 yp_p zp_m zp_m avdd sg13_hv_pmos ad=1.125p pd=5u as=1.125p ps=5u w=9u l=1u
X499 zp_p bnb a_52500_6600# avss sg13_hv_nmos ad=1.125p pd=5u as=1.125p ps=5u w=9u l=1u
X500 avdd bpa bnb avdd sg13_hv_pmos ad=1.125p pd=5u as=1.125p ps=5u w=9u l=7u
X501 avdd en bpa avdd sg13_hv_pmos ad=1.125p pd=5u as=1.125p ps=5u w=9u l=3u
X502 a_46700_600# bpb zn_m avdd sg13_hv_pmos ad=1.125p pd=5u as=1.125p ps=5u w=9u l=1u
X503 zp_p zp_m yp_m avdd sg13_hv_pmos ad=1.125p pd=5u as=1.125p ps=5u w=9u l=1u
X504 yn_m zn_m a_54100_5400# avss sg13_hv_nmos ad=1.125p pd=5u as=1.125p ps=5u w=9u l=1u
X505 avdd zp_p out avdd sg13_hv_pmos ad=1.125p pd=5u as=1.125p ps=5u w=9u l=1u
X506 bna_ bnb a_20500_6600# avss sg13_hv_nmos ad=1.125p pd=5u as=1.125p ps=5u w=9u l=1u
X507 xp bpa avdd avdd sg13_hv_pmos ad=1.125p pd=5u as=1.125p ps=5u w=9u l=7u
X508 yn_m in_p xp avdd sg13_hv_pmos ad=1.125p pd=5u as=1.125p ps=5u w=9u l=1u
X509 bna_ bnb a_22100_5400# avss sg13_hv_nmos ad=1.125p pd=5u as=1.125p ps=5u w=9u l=1u
X510 xn in_p a_27700_5400# avss sg13_hv_nmos ad=1.125p pd=5u as=1.125p ps=5u w=9u l=1u
X511 bna_ bna_ a_16500_5400# avss sg13_hv_nmos ad=1.125p pd=5u as=1.125p ps=5u w=9u l=1u
X512 a_16900_600# bpa_r avdd avdd sg13_hv_pmos ad=1.125p pd=5u as=1.125p ps=5u w=9u l=1u
X513 bpa_r bpb bpb avdd sg13_hv_pmos ad=1.125p pd=5u as=1.125p ps=5u w=9u l=1u
X514 avdd zp_m yp_p avdd sg13_hv_pmos ad=1.125p pd=5u as=1.125p ps=5u w=9u l=7u
X515 a_40100_6600# bnb a_39100_5400# avss sg13_hv_nmos ad=1.125p pd=5u as=1.125p ps=5u w=9u l=1u
X516 a_45700_6600# zn_m yn_p avss sg13_hv_nmos ad=1.125p pd=5u as=1.125p ps=5u w=9u l=1u
X517 a_43900_600# bpb zn_m avdd sg13_hv_pmos ad=1.125p pd=5u as=1.125p ps=5u w=9u l=1u
X518 avdd zp_m yp_m avdd sg13_hv_pmos ad=1.125p pd=5u as=1.125p ps=5u w=9u l=7u
X519 a_30300_6600# bna xn avss sg13_hv_nmos ad=1.125p pd=5u as=1.125p ps=5u w=9u l=7u
X520 a_42300_5400# bna a_39100_5400# avss sg13_hv_nmos ad=1.125p pd=5u as=1.125p ps=5u w=9u l=7u
X521 yp_m zp_m zp_p avdd sg13_hv_pmos ad=1.125p pd=5u as=1.125p ps=5u w=9u l=1u
X522 a_47900_5400# zn_m yn_p avss sg13_hv_nmos ad=1.125p pd=5u as=1.125p ps=5u w=9u l=7u
X523 a_24100_6600# bna_ a_23900_6600# avss sg13_hv_nmos ad=1.125p pd=5u as=1.125p ps=5u w=9u l=1u
X524 a_36700_5400# zn_m yn_p avss sg13_hv_nmos ad=1.125p pd=5u as=1.125p ps=5u w=9u l=7u
X525 out zp_p avdd avdd sg13_hv_pmos ad=1.125p pd=5u as=1.125p ps=5u w=9u l=1u
X526 avdd zp_p out avdd sg13_hv_pmos ad=1.125p pd=5u as=1.125p ps=5u w=9u l=1u
X527 a_57300_6600# zn_p out avss sg13_hv_nmos ad=1.125p pd=5u as=1.125p ps=5u w=9u l=1u
X528 xp in_p yn_m avdd sg13_hv_pmos ad=1.125p pd=5u as=1.125p ps=5u w=9u l=1u
X529 a_51700_6600# bnb zn_p avss sg13_hv_nmos ad=1.125p pd=5u as=1.125p ps=5u w=9u l=1u
X530 bpb bpb bpa_l avdd sg13_hv_pmos ad=1.125p pd=5u as=1.125p ps=5u w=9u l=1u
X531 a_58900_5400# zn_p out avss sg13_hv_nmos ad=1.125p pd=5u as=1.125p ps=5u w=9u l=1u
X532 bpb bpb bpa_r avdd sg13_hv_pmos ad=1.125p pd=5u as=1.125p ps=5u w=9u l=1u
X533 avdd zp_m yp_p avdd sg13_hv_pmos ad=1.125p pd=5u as=1.125p ps=5u w=9u l=7u
X534 a_53300_5400# zn_m zn_p avss sg13_hv_nmos ad=1.125p pd=5u as=1.125p ps=5u w=9u l=1u
X535 zn_m bpb a_43900_600# avdd sg13_hv_pmos ad=1.125p pd=5u as=1.125p ps=5u w=9u l=1u
X536 a_15700_5400# bna_ a_15500_5400# avss sg13_hv_nmos ad=1.125p pd=5u as=1.125p ps=5u w=9u l=1u
X537 a_21300_5400# bnb bnb avss sg13_hv_nmos ad=1.125p pd=5u as=1.125p ps=5u w=9u l=1u
X538 a_26900_5400# in_p yp_m avss sg13_hv_nmos ad=1.125p pd=5u as=1.125p ps=5u w=9u l=1u
X539 zp_p bpb zn_p avdd sg13_hv_pmos ad=1.125p pd=5u as=1.125p ps=5u w=9u l=1u
X540 avdd zp_m yp_m avdd sg13_hv_pmos ad=1.125p pd=5u as=1.125p ps=5u w=9u l=7u
X541 zp_p en avdd avdd sg13_hv_pmos ad=1.125p pd=5u as=1.125p ps=5u w=9u l=3u
X542 avdd bpa a_46700_600# avdd sg13_hv_pmos ad=1.125p pd=5u as=1.125p ps=5u w=9u l=7u
X543 yn_m in_p xp avdd sg13_hv_pmos ad=1.125p pd=5u as=1.125p ps=5u w=9u l=1u
X544 enb en avdd avdd sg13_hv_pmos ad=1.125p pd=5u as=2.25p ps=10u w=9u l=3u
X545 bpa_l bpb bpb avdd sg13_hv_pmos ad=1.125p pd=5u as=1.125p ps=5u w=9u l=1u
X546 a_39100_5400# bnb a_39700_6600# avss sg13_hv_nmos ad=1.125p pd=5u as=1.125p ps=5u w=9u l=1u
X547 xn in_m a_28500_6600# avss sg13_hv_nmos ad=1.125p pd=5u as=1.125p ps=5u w=9u l=1u
X548 a_39100_5400# bnb a_40500_5400# avss sg13_hv_nmos ad=1.125p pd=5u as=1.125p ps=5u w=9u l=1u
X549 bpa_r bpb bpb avdd sg13_hv_pmos ad=1.125p pd=5u as=1.125p ps=5u w=9u l=1u
X550 yn_p zn_m a_46100_5400# avss sg13_hv_nmos ad=1.125p pd=5u as=1.125p ps=5u w=9u l=1u
X551 a_11100_6600# bna bpa avss sg13_hv_nmos ad=1.125p pd=5u as=1.125p ps=5u w=9u l=7u
X552 bna_ bnb a_22900_6600# avss sg13_hv_nmos ad=1.125p pd=5u as=1.125p ps=5u w=9u l=1u
X553 a_17100_1800# bpa_r a_16900_1800# avdd sg13_hv_pmos ad=1.125p pd=5u as=1.125p ps=5u w=9u l=1u
X554 yn_p in_m xp avdd sg13_hv_pmos ad=1.125p pd=5u as=1.125p ps=5u w=9u l=1u
X555 a_7100_5400# bna bna avss sg13_hv_nmos ad=1.125p pd=5u as=1.125p ps=5u w=9u l=7u
X556 bna_ bnb a_18900_5400# avss sg13_hv_nmos ad=1.125p pd=5u as=1.125p ps=5u w=9u l=1u
X557 avss bna_ a_24500_5400# avss sg13_hv_nmos ad=1.125p pd=5u as=1.125p ps=5u w=9u l=1u
X558 out zn_p a_56100_6600# avss sg13_hv_nmos ad=1.125p pd=5u as=1.125p ps=5u w=9u l=1u
X559 zn_p zn_m a_50500_6600# avss sg13_hv_nmos ad=1.125p pd=5u as=1.125p ps=5u w=9u l=1u
X560 zn_p bpb zp_p avdd sg13_hv_pmos ad=1.125p pd=5u as=1.125p ps=5u w=9u l=1u
X561 out zn_p a_57700_5400# avss sg13_hv_nmos ad=1.125p pd=5u as=1.125p ps=5u w=9u l=1u
X562 yp_p zp_m avdd avdd sg13_hv_pmos ad=1.125p pd=5u as=1.125p ps=5u w=9u l=7u
X563 zn_p bnb a_52100_5400# avss sg13_hv_nmos ad=1.125p pd=5u as=1.125p ps=5u w=9u l=1u
X564 avss zn_m a_47900_6600# avss sg13_hv_nmos ad=1.125p pd=5u as=1.125p ps=5u w=9u l=7u
X565 avdd zp_p out avdd sg13_hv_pmos ad=1.125p pd=5u as=1.125p ps=5u w=9u l=1u
X566 bpb bpb bpa_l avdd sg13_hv_pmos ad=1.125p pd=5u as=1.125p ps=5u w=9u l=1u
X567 bnb bnb a_19300_6600# avss sg13_hv_nmos ad=1.125p pd=5u as=1.125p ps=5u w=9u l=1u
X568 yn_p zn_m a_43900_5400# avss sg13_hv_nmos ad=1.125p pd=5u as=1.125p ps=5u w=9u l=7u
X569 a_12100_1800# bpa_l avdd avdd sg13_hv_pmos ad=1.125p pd=5u as=1.125p ps=5u w=9u l=1u
X570 yn_m zn_m a_49500_5400# avss sg13_hv_nmos ad=1.125p pd=5u as=1.125p ps=5u w=9u l=7u
X571 bnb bnb a_20100_5400# avss sg13_hv_nmos ad=1.125p pd=5u as=1.125p ps=5u w=9u l=1u
X572 a_17300_1800# bpa_r a_17100_1800# avdd sg13_hv_pmos ad=1.125p pd=5u as=1.125p ps=5u w=9u l=1u
X573 xp in_m yn_p avdd sg13_hv_pmos ad=1.125p pd=5u as=1.125p ps=5u w=9u l=1u
X574 a_54100_6600# zn_m zn_p avss sg13_hv_nmos ad=1.125p pd=5u as=1.125p ps=5u w=9u l=1u
X575 avss enb zn_p avss sg13_hv_nmos ad=2.25p pd=10u as=1.125p ps=5u w=9u l=3u
X576 avdd bpa bnb avdd sg13_hv_pmos ad=1.125p pd=5u as=1.125p ps=5u w=9u l=7u
X577 zp_p bpb zn_p avdd sg13_hv_pmos ad=1.125p pd=5u as=1.125p ps=5u w=9u l=1u
X578 a_43900_600# bpa avdd avdd sg13_hv_pmos ad=1.125p pd=5u as=1.125p ps=5u w=9u l=7u
X579 a_27700_6600# in_p yp_m avss sg13_hv_nmos ad=1.125p pd=5u as=1.125p ps=5u w=9u l=1u
X580 a_45300_5400# zn_m zn_m avss sg13_hv_nmos ad=1.125p pd=5u as=1.125p ps=5u w=9u l=1u
X581 a_22100_6600# bnb bnb avss sg13_hv_nmos ad=1.125p pd=5u as=1.125p ps=5u w=9u l=1u
X582 out zp_p avdd avdd sg13_hv_pmos ad=1.125p pd=5u as=1.125p ps=5u w=9u l=1u
X583 a_29300_5400# in_m yp_p avss sg13_hv_nmos ad=1.125p pd=5u as=1.125p ps=5u w=9u l=1u
X584 avdd zp_m yp_m avdd sg13_hv_pmos ad=1.125p pd=5u as=1.125p ps=5u w=9u l=7u
X585 a_46700_600# bpa avdd avdd sg13_hv_pmos ad=1.125p pd=5u as=1.125p ps=5u w=9u l=7u
X586 a_18100_5400# bnb bnb avss sg13_hv_nmos ad=1.125p pd=5u as=1.125p ps=5u w=9u l=1u
X587 a_23700_5400# bna_ a_23500_5400# avss sg13_hv_nmos ad=1.125p pd=5u as=1.125p ps=5u w=9u l=1u
X588 a_12300_1800# bpa_l a_12100_1800# avdd sg13_hv_pmos ad=1.125p pd=5u as=1.125p ps=5u w=9u l=1u
X589 enb en avss avss sg13_hv_nmos ad=1.125p pd=5u as=2.25p ps=10u w=9u l=3u
X590 avss zn_m a_55100_6600# avss sg13_hv_nmos ad=1.125p pd=5u as=1.125p ps=5u w=9u l=7u
X591 xp in_p yn_m avdd sg13_hv_pmos ad=1.125p pd=5u as=1.125p ps=5u w=9u l=1u
X592 bpa_r bpa_r a_17300_1800# avdd sg13_hv_pmos ad=1.125p pd=5u as=1.125p ps=5u w=9u l=1u
X593 bna bna a_4700_5400# avss sg13_hv_nmos ad=1.125p pd=5u as=1.125p ps=5u w=9u l=7u
X594 a_56900_5400# zn_p avss avss sg13_hv_nmos ad=1.125p pd=5u as=1.125p ps=5u w=9u l=1u
X595 bpb bpb bpa_r avdd sg13_hv_pmos ad=1.125p pd=5u as=1.125p ps=5u w=9u l=1u
X596 a_51300_5400# zn_m yn_m avss sg13_hv_nmos ad=1.125p pd=5u as=1.125p ps=5u w=9u l=1u
X597 yn_p zn_m a_46900_6600# avss sg13_hv_nmos ad=1.125p pd=5u as=1.125p ps=5u w=9u l=1u
X598 yp_m bpa avdd avdd sg13_hv_pmos ad=1.125p pd=5u as=1.125p ps=5u w=9u l=7u
X599 bpb bna a_12700_6600# avss sg13_hv_nmos ad=1.125p pd=5u as=1.125p ps=5u w=9u l=7u
X600 a_18500_6600# bnb bna_ avss sg13_hv_nmos ad=1.125p pd=5u as=1.125p ps=5u w=9u l=1u
X601 avss bna a_30300_5400# avss sg13_hv_nmos ad=1.125p pd=5u as=1.125p ps=5u w=9u l=7u
X602 avss bna a_7100_6600# avss sg13_hv_nmos ad=1.125p pd=5u as=1.125p ps=5u w=9u l=7u
X603 bpa_r bpb bpb avdd sg13_hv_pmos ad=1.125p pd=5u as=1.125p ps=5u w=9u l=1u
X604 avss bna a_14300_5400# avss sg13_hv_nmos ad=1.125p pd=5u as=1.125p ps=5u w=9u l=7u
X605 avdd zp_p out avdd sg13_hv_pmos ad=1.125p pd=5u as=1.125p ps=5u w=9u l=1u
X606 a_9500_5400# bna avss avss sg13_hv_nmos ad=1.125p pd=5u as=1.125p ps=5u w=9u l=7u
X607 avdd en zp_p avdd sg13_hv_pmos ad=2.25p pd=10u as=1.125p ps=5u w=9u l=3u
X608 zn_p bnb a_52900_6600# avss sg13_hv_nmos ad=1.125p pd=5u as=1.125p ps=5u w=9u l=1u
X609 out zn_p a_58500_6600# avss sg13_hv_nmos ad=1.125p pd=5u as=1.125p ps=5u w=9u l=1u
X610 yp_p zp_m avdd avdd sg13_hv_pmos ad=1.125p pd=5u as=1.125p ps=5u w=9u l=7u
X611 a_12500_1800# bpa_l a_12300_1800# avdd sg13_hv_pmos ad=1.125p pd=5u as=1.125p ps=5u w=9u l=1u
X612 bpa_l bpb bpb avdd sg13_hv_pmos ad=1.125p pd=5u as=1.125p ps=5u w=9u l=1u
X613 yn_m in_p xp avdd sg13_hv_pmos ad=1.125p pd=5u as=1.125p ps=5u w=9u l=1u
X614 tihi tihi avdd avdd sg13_hv_pmos ad=1.125p pd=5u as=1.125p ps=5u w=9u l=19u
X615 yp_m in_p a_26500_6600# avss sg13_hv_nmos ad=1.125p pd=5u as=1.125p ps=5u w=9u l=1u
X616 bpa_r bpb bpb avdd sg13_hv_pmos ad=1.125p pd=5u as=1.125p ps=5u w=9u l=1u
X617 bnb bnb a_20900_6600# avss sg13_hv_nmos ad=1.125p pd=5u as=1.125p ps=5u w=9u l=1u
X618 zp_m bnb a_39300_5400# avss sg13_hv_nmos ad=1.125p pd=5u as=1.125p ps=5u w=9u l=1u
X619 zp_m zp_m yp_p avdd sg13_hv_pmos ad=1.125p pd=5u as=1.125p ps=5u w=9u l=1u
X620 yp_p in_m a_28100_5400# avss sg13_hv_nmos ad=1.125p pd=5u as=1.125p ps=5u w=9u l=1u
X621 bpb bpb bpa_l avdd sg13_hv_pmos ad=1.125p pd=5u as=1.125p ps=5u w=9u l=1u
X622 yn_p in_m xp avdd sg13_hv_pmos ad=1.125p pd=5u as=1.125p ps=5u w=9u l=1u
X623 bnb bnb a_16900_5400# avss sg13_hv_nmos ad=1.125p pd=5u as=1.125p ps=5u w=9u l=1u
X624 bnb bnb a_22500_5400# avss sg13_hv_nmos ad=1.125p pd=5u as=1.125p ps=5u w=9u l=1u
X625 yp_m zp_m avdd avdd sg13_hv_pmos ad=1.125p pd=5u as=1.125p ps=5u w=9u l=7u
X626 a_20900_600# bpa_r bpa_r avdd sg13_hv_pmos ad=1.125p pd=5u as=1.125p ps=5u w=9u l=1u
X627 yp_m zp_m zp_p avdd sg13_hv_pmos ad=1.125p pd=5u as=1.125p ps=5u w=9u l=1u
X628 zp_m zp_m yp_p avdd sg13_hv_pmos ad=1.125p pd=5u as=1.125p ps=5u w=9u l=1u
X629 avdd bpa bpa avdd sg13_hv_pmos ad=1.125p pd=5u as=1.125p ps=5u w=9u l=7u
X630 a_46100_6600# zn_m zn_m avss sg13_hv_nmos ad=1.125p pd=5u as=1.125p ps=5u w=9u l=1u
X631 bpb bpb bpa_l avdd sg13_hv_pmos ad=1.125p pd=5u as=1.125p ps=5u w=9u l=1u
X632 bna_ bnb a_17300_6600# avss sg13_hv_nmos ad=1.125p pd=5u as=1.125p ps=5u w=9u l=1u
X633 xp in_p yn_m avdd sg13_hv_pmos ad=1.125p pd=5u as=1.125p ps=5u w=9u l=1u
X634 bpa_l bpb bpb avdd sg13_hv_pmos ad=1.125p pd=5u as=1.125p ps=5u w=9u l=1u
X635 xp in_m yn_p avdd sg13_hv_pmos ad=1.125p pd=5u as=1.125p ps=5u w=9u l=1u
X636 a_52100_6600# bnb zp_p avss sg13_hv_nmos ad=1.125p pd=5u as=1.125p ps=5u w=9u l=1u
X637 a_57700_6600# zn_p avss avss sg13_hv_nmos ad=1.125p pd=5u as=1.125p ps=5u w=9u l=1u
X638 bpb bpb bpa_r avdd sg13_hv_pmos ad=1.125p pd=5u as=1.125p ps=5u w=9u l=1u
X639 zp_p zp_m yp_m avdd sg13_hv_pmos ad=1.125p pd=5u as=1.125p ps=5u w=9u l=1u
X640 yp_p zp_m zp_m avdd sg13_hv_pmos ad=1.125p pd=5u as=1.125p ps=5u w=9u l=1u
X641 zn_p enb avss avss sg13_hv_nmos ad=1.125p pd=5u as=1.125p ps=5u w=9u l=3u
X642 a_53700_5400# zn_m yn_m avss sg13_hv_nmos ad=1.125p pd=5u as=1.125p ps=5u w=9u l=1u
X643 avss zn_m a_36700_6600# avss sg13_hv_nmos ad=1.125p pd=5u as=1.125p ps=5u w=9u l=7u
X644 avss bna a_42300_6600# avss sg13_hv_nmos ad=1.125p pd=5u as=1.125p ps=5u w=9u l=7u
X645 bnb bpa avdd avdd sg13_hv_pmos ad=1.125p pd=5u as=1.125p ps=5u w=9u l=7u
X646 xn bna a_25500_6600# avss sg13_hv_nmos ad=1.125p pd=5u as=1.125p ps=5u w=9u l=7u
X647 a_31900_6600# zn_m avss avss sg13_hv_nmos ad=1.125p pd=5u as=1.125p ps=5u w=9u l=7u
X648 zn_p bpb zp_p avdd sg13_hv_pmos ad=1.125p pd=5u as=1.125p ps=5u w=9u l=1u
X649 a_20100_6600# bnb bna_ avss sg13_hv_nmos ad=1.125p pd=5u as=1.125p ps=5u w=9u l=1u
X650 a_39100_5400# bna a_38300_5400# avss sg13_hv_nmos ad=1.125p pd=5u as=1.125p ps=5u w=9u l=7u
X651 yp_m zp_m avdd avdd sg13_hv_pmos ad=1.125p pd=5u as=1.125p ps=5u w=9u l=7u
X652 bpa bna a_9500_6600# avss sg13_hv_nmos ad=1.125p pd=5u as=1.125p ps=5u w=9u l=7u
X653 a_27300_5400# in_p xn avss sg13_hv_nmos ad=1.125p pd=5u as=1.125p ps=5u w=9u l=1u
X654 a_33500_5400# zn_m yn_m avss sg13_hv_nmos ad=1.125p pd=5u as=1.125p ps=5u w=9u l=7u
X655 a_16100_5400# bna_ a_15900_5400# avss sg13_hv_nmos ad=1.125p pd=5u as=1.125p ps=5u w=9u l=1u
X656 a_21700_5400# bnb bna_ avss sg13_hv_nmos ad=1.125p pd=5u as=1.125p ps=5u w=9u l=1u
X657 out zp_p a_57900_600# avdd sg13_hv_pmos ad=1.125p pd=5u as=1.125p ps=5u w=9u l=1u
X658 xp bpa avdd avdd sg13_hv_pmos ad=1.125p pd=5u as=1.125p ps=5u w=9u l=7u
X659 bpa_l bpb bpb avdd sg13_hv_pmos ad=1.125p pd=5u as=1.125p ps=5u w=9u l=1u
X660 zn_m zn_m a_44900_6600# avss sg13_hv_nmos ad=1.125p pd=5u as=1.125p ps=5u w=9u l=1u
X661 yn_p in_m xp avdd sg13_hv_pmos ad=1.125p pd=5u as=1.125p ps=5u w=9u l=1u
X662 bpa_r bpb bpb avdd sg13_hv_pmos ad=1.125p pd=5u as=1.125p ps=5u w=9u l=1u
X663 yp_p zp_m zp_m avdd sg13_hv_pmos ad=1.125p pd=5u as=1.125p ps=5u w=9u l=1u
.ends

.subckt lpopamp_sliceA in_m in_p out avss avdd ib en zp_p zn_p
X0 yp_p zp_m zp_m avdd sg13_hv_pmos ad=1.125p pd=5u as=1.125p ps=5u w=9u l=1u
X1 a_43900_5000# bpb zn_m avdd sg13_hv_pmos ad=1.125p pd=5u as=1.125p ps=5u w=9u l=1u
X2 bna_ bnb a_20500_1400# avss sg13_hv_nmos ad=1.125p pd=5u as=1.125p ps=5u w=9u l=1u
X3 yp_m zp_m zp_p avdd sg13_hv_pmos ad=1.125p pd=5u as=1.125p ps=5u w=9u l=1u
X4 bpb bpb bpa_r avdd sg13_hv_pmos ad=1.125p pd=5u as=1.125p ps=5u w=9u l=1u
X5 xp in_m yn_p avdd sg13_hv_pmos ad=1.125p pd=5u as=1.125p ps=5u w=9u l=1u
X6 bna_ bnb a_17300_200# avss sg13_hv_nmos ad=1.125p pd=5u as=1.125p ps=5u w=9u l=1u
X7 zp_p zp_m yp_m avdd sg13_hv_pmos ad=1.125p pd=5u as=1.125p ps=5u w=9u l=1u
X8 out zp_p a_58700_6200# avdd sg13_hv_pmos ad=1.125p pd=5u as=1.125p ps=5u w=9u l=1u
X9 a_28100_1400# in_p xn avss sg13_hv_nmos ad=1.125p pd=5u as=1.125p ps=5u w=9u l=1u
X10 yp_m zp_m zp_p avdd sg13_hv_pmos ad=1.125p pd=5u as=1.125p ps=5u w=9u l=1u
X11 yn_p in_m xp avdd sg13_hv_pmos ad=1.125p pd=5u as=1.125p ps=5u w=9u l=1u
X12 bpb bpb bpa_l avdd sg13_hv_pmos ad=1.125p pd=5u as=1.125p ps=5u w=9u l=1u
X13 a_21300_6200# bpa_r a_21100_6200# avdd sg13_hv_pmos ad=1.125p pd=5u as=1.125p ps=5u w=9u l=1u
X14 a_4700_1400# bna avss avss sg13_hv_nmos ad=1.125p pd=5u as=1.125p ps=5u w=9u l=7u
X15 a_27300_200# in_m xn avss sg13_hv_nmos ad=1.125p pd=5u as=1.125p ps=5u w=9u l=1u
X16 zp_p bnb a_51700_200# avss sg13_hv_nmos ad=1.125p pd=5u as=1.125p ps=5u w=9u l=1u
X17 a_39100_200# bna a_38300_1400# avss sg13_hv_nmos ad=1.125p pd=5u as=1.125p ps=5u w=9u l=7u
X18 a_39100_200# bnb a_39700_200# avss sg13_hv_nmos ad=1.125p pd=5u as=1.125p ps=5u w=9u l=1u
X19 a_15700_1400# bna_ a_15500_1400# avss sg13_hv_nmos ad=1.125p pd=5u as=1.125p ps=5u w=9u l=1u
X20 bna bna a_4700_200# avss sg13_hv_nmos ad=1.125p pd=5u as=1.125p ps=5u w=9u l=7u
X21 bpa_l bpa_l a_12500_5000# avdd sg13_hv_pmos ad=1.125p pd=5u as=1.125p ps=5u w=9u l=1u
X22 bpa_r bpb bpb avdd sg13_hv_pmos ad=1.125p pd=5u as=1.125p ps=5u w=9u l=1u
X23 a_20900_1400# bnb bna_ avss sg13_hv_nmos ad=1.125p pd=5u as=1.125p ps=5u w=9u l=1u
X24 bnb bnb a_19300_200# avss sg13_hv_nmos ad=1.125p pd=5u as=1.125p ps=5u w=9u l=1u
X25 bna_ bnb a_22900_1400# avss sg13_hv_nmos ad=1.125p pd=5u as=1.125p ps=5u w=9u l=1u
X26 a_39100_200# bnb a_41300_200# avss sg13_hv_nmos ad=1.125p pd=5u as=1.125p ps=5u w=9u l=1u
X27 yp_m zp_m zp_p avdd sg13_hv_pmos ad=1.125p pd=5u as=1.125p ps=5u w=9u l=1u
X28 yn_m zn_m a_49500_200# avss sg13_hv_nmos ad=1.125p pd=5u as=1.125p ps=5u w=9u l=7u
X29 yp_m in_p a_28100_1400# avss sg13_hv_nmos ad=1.125p pd=5u as=1.125p ps=5u w=9u l=1u
X30 bpa_r bpb bpb avdd sg13_hv_pmos ad=1.125p pd=5u as=1.125p ps=5u w=9u l=1u
X31 bna_ bna_ a_16500_200# avss sg13_hv_nmos ad=1.125p pd=5u as=1.125p ps=5u w=9u l=1u
X32 yp_p zp_m avdd avdd sg13_hv_pmos ad=1.125p pd=5u as=1.125p ps=5u w=9u l=7u
X33 a_43900_5000# bpa avdd avdd sg13_hv_pmos ad=1.125p pd=5u as=1.125p ps=5u w=9u l=7u
X34 a_29300_200# in_p yp_m avss sg13_hv_nmos ad=1.125p pd=5u as=1.125p ps=5u w=9u l=1u
X35 yp_m zp_m avdd avdd sg13_hv_pmos ad=1.125p pd=5u as=1.125p ps=5u w=9u l=7u
X36 yn_p in_m xp avdd sg13_hv_pmos ad=1.125p pd=5u as=1.125p ps=5u w=9u l=1u
X37 zn_p zn_m a_53700_200# avss sg13_hv_nmos ad=1.125p pd=5u as=1.125p ps=5u w=9u l=1u
X38 a_57900_6200# zp_p out avdd sg13_hv_pmos ad=1.125p pd=5u as=1.125p ps=5u w=9u l=1u
X39 a_15900_1400# bna_ a_15700_1400# avss sg13_hv_nmos ad=1.125p pd=5u as=1.125p ps=5u w=9u l=1u
X40 a_9500_200# bna avss avss sg13_hv_nmos ad=1.125p pd=5u as=1.125p ps=5u w=9u l=7u
X41 a_18100_1400# bnb bnb avss sg13_hv_nmos ad=1.125p pd=5u as=1.125p ps=5u w=9u l=1u
X42 zp_p zp_m yp_m avdd sg13_hv_pmos ad=1.125p pd=5u as=1.125p ps=5u w=9u l=1u
X43 yn_m zn_m a_50900_200# avss sg13_hv_nmos ad=1.125p pd=5u as=1.125p ps=5u w=9u l=1u
X44 zn_m bpb a_43900_5000# avdd sg13_hv_pmos ad=1.125p pd=5u as=1.125p ps=5u w=9u l=1u
X45 a_23300_1400# bna_ bna_ avss sg13_hv_nmos ad=1.125p pd=5u as=1.125p ps=5u w=9u l=1u
X46 bpa_r bpb bpb avdd sg13_hv_pmos ad=1.125p pd=5u as=1.125p ps=5u w=9u l=1u
X47 zp_p zp_m yp_m avdd sg13_hv_pmos ad=1.125p pd=5u as=1.125p ps=5u w=9u l=1u
X48 a_4700_200# bna avss avss sg13_hv_nmos ad=1.125p pd=5u as=1.125p ps=5u w=9u l=7u
X49 zn_p zn_m a_50500_1400# avss sg13_hv_nmos ad=1.125p pd=5u as=1.125p ps=5u w=9u l=1u
X50 bna en ib avss sg13_hv_nmos ad=1.125p pd=5u as=1.125p ps=5u w=9u l=3u
X51 a_28500_1400# in_p yp_m avss sg13_hv_nmos ad=1.125p pd=5u as=1.125p ps=5u w=9u l=1u
X52 a_11100_200# bna bpa avss sg13_hv_nmos ad=1.125p pd=5u as=1.125p ps=5u w=9u l=7u
X53 bnb bnb a_18500_200# avss sg13_hv_nmos ad=1.125p pd=5u as=1.125p ps=5u w=9u l=1u
X54 ib en bna avss sg13_hv_nmos ad=1.125p pd=5u as=1.125p ps=5u w=9u l=3u
X55 a_58100_1400# zn_p out avss sg13_hv_nmos ad=1.125p pd=5u as=1.125p ps=5u w=9u l=1u
X56 a_17300_5000# bpa_r a_17100_5000# avdd sg13_hv_pmos ad=1.125p pd=5u as=1.125p ps=5u w=9u l=1u
X57 a_39100_200# bnb a_40500_200# avss sg13_hv_nmos ad=1.125p pd=5u as=1.125p ps=5u w=9u l=1u
X58 avdd tihi tihi avdd sg13_hv_pmos ad=1.125p pd=5u as=1.125p ps=5u w=9u l=19u
X59 avdd bpa a_43900_5000# avdd sg13_hv_pmos ad=1.125p pd=5u as=1.125p ps=5u w=9u l=7u
X60 bnb bnb a_20100_200# avss sg13_hv_nmos ad=1.125p pd=5u as=1.125p ps=5u w=9u l=1u
X61 zp_p bpb zn_p avdd sg13_hv_pmos ad=1.125p pd=5u as=1.125p ps=5u w=9u l=1u
X62 bna_ bnb a_18100_1400# avss sg13_hv_nmos ad=1.125p pd=5u as=1.125p ps=5u w=9u l=1u
X63 zn_p bnb a_52900_200# avss sg13_hv_nmos ad=1.125p pd=5u as=1.125p ps=5u w=9u l=1u
X64 bpb bpb bpa_r avdd sg13_hv_pmos ad=1.125p pd=5u as=1.125p ps=5u w=9u l=1u
X65 a_33500_200# zn_m yn_p avss sg13_hv_nmos ad=1.125p pd=5u as=1.125p ps=5u w=9u l=7u
X66 avss zn_p a_57300_200# avss sg13_hv_nmos ad=1.125p pd=5u as=1.125p ps=5u w=9u l=1u
X67 a_23500_1400# bna_ a_23300_1400# avss sg13_hv_nmos ad=1.125p pd=5u as=1.125p ps=5u w=9u l=1u
X68 a_46700_5000# bpb zn_m avdd sg13_hv_pmos ad=1.125p pd=5u as=1.125p ps=5u w=9u l=1u
X69 xp in_p yn_m avdd sg13_hv_pmos ad=1.125p pd=5u as=1.125p ps=5u w=9u l=1u
X70 yp_p zp_m zp_m avdd sg13_hv_pmos ad=1.125p pd=5u as=1.125p ps=5u w=9u l=1u
X71 a_50900_1400# zn_m zn_p avss sg13_hv_nmos ad=1.125p pd=5u as=1.125p ps=5u w=9u l=1u
X72 bna enb avss avss sg13_hv_nmos ad=1.125p pd=5u as=1.125p ps=5u w=9u l=3u
X73 zp_p zp_m yp_m avdd sg13_hv_pmos ad=1.125p pd=5u as=1.125p ps=5u w=9u l=1u
X74 out zp_p avdd avdd sg13_hv_pmos ad=1.125p pd=5u as=1.125p ps=5u w=9u l=1u
X75 zn_p bnb a_52900_1400# avss sg13_hv_nmos ad=1.125p pd=5u as=1.125p ps=5u w=9u l=1u
X76 avss zn_p a_58100_1400# avss sg13_hv_nmos ad=1.125p pd=5u as=1.125p ps=5u w=9u l=1u
X77 bna enb avss avss sg13_hv_nmos ad=1.125p pd=5u as=1.125p ps=5u w=9u l=3u
X78 yn_p zn_m a_46900_1400# avss sg13_hv_nmos ad=1.125p pd=5u as=1.125p ps=5u w=9u l=1u
X79 avdd bpa yp_m avdd sg13_hv_pmos ad=1.125p pd=5u as=1.125p ps=5u w=9u l=7u
X80 zn_p bpb zp_p avdd sg13_hv_pmos ad=1.125p pd=5u as=1.125p ps=5u w=9u l=1u
X81 bpb bpb bpa_l avdd sg13_hv_pmos ad=1.125p pd=5u as=1.125p ps=5u w=9u l=1u
X82 bna_ bnb a_22100_200# avss sg13_hv_nmos ad=1.125p pd=5u as=1.125p ps=5u w=9u l=1u
X83 a_18500_1400# bnb bna_ avss sg13_hv_nmos ad=1.125p pd=5u as=1.125p ps=5u w=9u l=1u
X84 bpa bpa avdd avdd sg13_hv_pmos ad=1.125p pd=5u as=1.125p ps=5u w=9u l=7u
X85 a_16300_5000# bpa_l a_16100_5000# avdd sg13_hv_pmos ad=1.125p pd=5u as=1.125p ps=5u w=9u l=1u
X86 yp_m zp_m zp_p avdd sg13_hv_pmos ad=1.125p pd=5u as=1.125p ps=5u w=9u l=1u
X87 avss bna a_14300_200# avss sg13_hv_nmos ad=1.125p pd=5u as=1.125p ps=5u w=9u l=7u
X88 a_53300_1400# zn_m zn_p avss sg13_hv_nmos ad=1.125p pd=5u as=1.125p ps=5u w=9u l=1u
X89 yn_p zn_m a_31900_200# avss sg13_hv_nmos ad=1.125p pd=5u as=1.125p ps=5u w=9u l=7u
X90 avss zn_p a_56500_200# avss sg13_hv_nmos ad=1.125p pd=5u as=1.125p ps=5u w=9u l=1u
X91 yp_p zp_m zp_m avdd sg13_hv_pmos ad=1.125p pd=5u as=1.125p ps=5u w=9u l=1u
X92 a_58500_1400# zn_p avss avss sg13_hv_nmos ad=1.125p pd=5u as=1.125p ps=5u w=9u l=1u
X93 a_47900_1400# zn_m yn_p avss sg13_hv_nmos ad=1.125p pd=5u as=1.125p ps=5u w=9u l=7u
X94 a_17100_6200# bpa_r a_16900_6200# avdd sg13_hv_pmos ad=1.125p pd=5u as=1.125p ps=5u w=9u l=1u
X95 zn_m bpb a_46700_5000# avdd sg13_hv_pmos ad=1.125p pd=5u as=1.125p ps=5u w=9u l=1u
X96 yn_m in_p xp avdd sg13_hv_pmos ad=1.125p pd=5u as=1.125p ps=5u w=9u l=1u
X97 zp_m zp_m yp_p avdd sg13_hv_pmos ad=1.125p pd=5u as=1.125p ps=5u w=9u l=1u
X98 a_24300_200# bna_ a_24100_200# avss sg13_hv_nmos ad=1.125p pd=5u as=1.125p ps=5u w=9u l=1u
X99 zn_p bpb zp_p avdd sg13_hv_pmos ad=1.125p pd=5u as=1.125p ps=5u w=9u l=1u
X100 yn_p zn_m a_46100_200# avss sg13_hv_nmos ad=1.125p pd=5u as=1.125p ps=5u w=9u l=1u
X101 bpb bpb bpa_l avdd sg13_hv_pmos ad=1.125p pd=5u as=1.125p ps=5u w=9u l=1u
X102 bpb bpb bpa_r avdd sg13_hv_pmos ad=1.125p pd=5u as=1.125p ps=5u w=9u l=1u
X103 zn_m bpb a_46700_5000# avdd sg13_hv_pmos ad=1.125p pd=5u as=1.125p ps=5u w=9u l=1u
X104 zp_m zp_m yp_p avdd sg13_hv_pmos ad=1.125p pd=5u as=1.125p ps=5u w=9u l=1u
X105 a_50500_200# zn_m yn_m avss sg13_hv_nmos ad=1.125p pd=5u as=1.125p ps=5u w=9u l=1u
X106 yn_m zn_m a_53300_1400# avss sg13_hv_nmos ad=1.125p pd=5u as=1.125p ps=5u w=9u l=1u
X107 out zp_p avdd avdd sg13_hv_pmos ad=1.125p pd=5u as=1.125p ps=5u w=9u l=1u
X108 a_39100_200# bna a_38300_200# avss sg13_hv_nmos ad=1.125p pd=5u as=1.125p ps=5u w=9u l=7u
X109 out zn_p a_58500_200# avss sg13_hv_nmos ad=1.125p pd=5u as=1.125p ps=5u w=9u l=1u
X110 bpa_l bpb bpb avdd sg13_hv_pmos ad=1.125p pd=5u as=1.125p ps=5u w=9u l=1u
X111 avss enb bna avss sg13_hv_nmos ad=1.125p pd=5u as=1.125p ps=5u w=9u l=3u
X112 a_20900_5000# bpa_r bpa_r avdd sg13_hv_pmos ad=1.125p pd=5u as=1.125p ps=5u w=9u l=1u
X113 yp_p zp_m avdd avdd sg13_hv_pmos ad=1.125p pd=5u as=1.125p ps=5u w=9u l=7u
X114 yp_p zp_m zp_m avdd sg13_hv_pmos ad=1.125p pd=5u as=1.125p ps=5u w=9u l=1u
X115 a_43900_5000# bpb zn_m avdd sg13_hv_pmos ad=1.125p pd=5u as=1.125p ps=5u w=9u l=1u
X116 a_14300_200# bna bpb avss sg13_hv_nmos ad=1.125p pd=5u as=1.125p ps=5u w=9u l=7u
X117 yn_m zn_m a_49500_1400# avss sg13_hv_nmos ad=1.125p pd=5u as=1.125p ps=5u w=9u l=7u
X118 bpb bpb bpa_l avdd sg13_hv_pmos ad=1.125p pd=5u as=1.125p ps=5u w=9u l=1u
X119 zp_p zp_m yp_m avdd sg13_hv_pmos ad=1.125p pd=5u as=1.125p ps=5u w=9u l=1u
X120 zp_p en avdd avdd sg13_hv_pmos ad=1.125p pd=5u as=1.125p ps=5u w=9u l=3u
X121 yn_p zn_m a_31900_1400# avss sg13_hv_nmos ad=1.125p pd=5u as=1.125p ps=5u w=9u l=7u
X122 zp_m zp_m yp_p avdd sg13_hv_pmos ad=1.125p pd=5u as=1.125p ps=5u w=9u l=1u
X123 a_15300_200# bna_ avss avss sg13_hv_nmos ad=1.125p pd=5u as=1.125p ps=5u w=9u l=1u
X124 bnb bpa avdd avdd sg13_hv_pmos ad=1.125p pd=5u as=1.125p ps=5u w=9u l=7u
X125 avdd zp_m yp_p avdd sg13_hv_pmos ad=1.125p pd=5u as=1.125p ps=5u w=9u l=7u
X126 yn_p in_m xp avdd sg13_hv_pmos ad=1.125p pd=5u as=1.125p ps=5u w=9u l=1u
X127 a_16100_6200# bpa_l bpa_l avdd sg13_hv_pmos ad=1.125p pd=5u as=1.125p ps=5u w=9u l=1u
X128 xn in_m a_27700_200# avss sg13_hv_nmos ad=1.125p pd=5u as=1.125p ps=5u w=9u l=1u
X129 a_52500_200# bnb zn_p avss sg13_hv_nmos ad=1.125p pd=5u as=1.125p ps=5u w=9u l=1u
X130 avss bna a_42300_1400# avss sg13_hv_nmos ad=1.125p pd=5u as=1.125p ps=5u w=9u l=7u
X131 bpa_l bpb bpb avdd sg13_hv_pmos ad=1.125p pd=5u as=1.125p ps=5u w=9u l=1u
X132 bpa_r bpb bpb avdd sg13_hv_pmos ad=1.125p pd=5u as=1.125p ps=5u w=9u l=1u
X133 a_38300_200# bna avss avss sg13_hv_nmos ad=1.125p pd=5u as=1.125p ps=5u w=9u l=7u
X134 xn in_m a_26900_1400# avss sg13_hv_nmos ad=1.125p pd=5u as=1.125p ps=5u w=9u l=1u
X135 avdd zp_p out avdd sg13_hv_pmos ad=1.125p pd=5u as=1.125p ps=5u w=9u l=1u
X136 a_12500_6200# bpa_l a_12300_6200# avdd sg13_hv_pmos ad=1.125p pd=5u as=1.125p ps=5u w=9u l=1u
X137 a_17300_200# bnb bnb avss sg13_hv_nmos ad=1.125p pd=5u as=1.125p ps=5u w=9u l=1u
X138 a_55100_200# zn_m yn_m avss sg13_hv_nmos ad=1.125p pd=5u as=1.125p ps=5u w=9u l=7u
X139 a_39700_1400# bnb zp_m avss sg13_hv_nmos ad=1.125p pd=5u as=1.125p ps=5u w=9u l=1u
X140 avdd zp_p out avdd sg13_hv_pmos ad=1.125p pd=5u as=1.125p ps=5u w=9u l=1u
X141 a_44900_1400# zn_m yn_p avss sg13_hv_nmos ad=1.125p pd=5u as=1.125p ps=5u w=9u l=1u
X142 a_22100_1400# bnb bnb avss sg13_hv_nmos ad=1.125p pd=5u as=1.125p ps=5u w=9u l=1u
X143 a_51700_200# bnb zn_p avss sg13_hv_nmos ad=1.125p pd=5u as=1.125p ps=5u w=9u l=1u
X144 xn in_m a_26900_200# avss sg13_hv_nmos ad=1.125p pd=5u as=1.125p ps=5u w=9u l=1u
X145 bpa_r bpb bpb avdd sg13_hv_pmos ad=1.125p pd=5u as=1.125p ps=5u w=9u l=1u
X146 a_39700_200# bnb zp_m avss sg13_hv_nmos ad=1.125p pd=5u as=1.125p ps=5u w=9u l=1u
X147 a_27300_1400# in_m xn avss sg13_hv_nmos ad=1.125p pd=5u as=1.125p ps=5u w=9u l=1u
X148 bpa_l bpb bpb avdd sg13_hv_pmos ad=1.125p pd=5u as=1.125p ps=5u w=9u l=1u
X149 enb en avss avss sg13_hv_nmos ad=1.125p pd=5u as=2.25p ps=10u w=9u l=3u
X150 xp bpa avdd avdd sg13_hv_pmos ad=1.125p pd=5u as=1.125p ps=5u w=9u l=7u
X151 a_19300_200# bnb bna_ avss sg13_hv_nmos ad=1.125p pd=5u as=1.125p ps=5u w=9u l=1u
X152 bnb bpa avdd avdd sg13_hv_pmos ad=1.125p pd=5u as=1.125p ps=5u w=9u l=7u
X153 avdd zp_m yp_m avdd sg13_hv_pmos ad=1.125p pd=5u as=1.125p ps=5u w=9u l=7u
X154 a_41300_200# bnb zp_m avss sg13_hv_nmos ad=1.125p pd=5u as=1.125p ps=5u w=9u l=1u
X155 a_12100_5000# bpa_l avdd avdd sg13_hv_pmos ad=1.125p pd=5u as=1.125p ps=5u w=9u l=1u
X156 bpb bpb bpa_r avdd sg13_hv_pmos ad=1.125p pd=5u as=1.125p ps=5u w=9u l=1u
X157 a_39100_200# bnb a_39700_1400# avss sg13_hv_nmos ad=1.125p pd=5u as=1.125p ps=5u w=9u l=1u
X158 bnb bnb a_16900_1400# avss sg13_hv_nmos ad=1.125p pd=5u as=1.125p ps=5u w=9u l=1u
X159 a_20900_200# bnb bna_ avss sg13_hv_nmos ad=1.125p pd=5u as=1.125p ps=5u w=9u l=1u
X160 out zp_p avdd avdd sg13_hv_pmos ad=1.125p pd=5u as=1.125p ps=5u w=9u l=1u
X161 zp_p bpb zn_p avdd sg13_hv_pmos ad=1.125p pd=5u as=1.125p ps=5u w=9u l=1u
X162 yp_m in_p a_28900_200# avss sg13_hv_nmos ad=1.125p pd=5u as=1.125p ps=5u w=9u l=1u
X163 bna_ bnb a_22100_1400# avss sg13_hv_nmos ad=1.125p pd=5u as=1.125p ps=5u w=9u l=1u
X164 avdd bpa bnb avdd sg13_hv_pmos ad=1.125p pd=5u as=1.125p ps=5u w=9u l=7u
X165 yp_m zp_m avdd avdd sg13_hv_pmos ad=1.125p pd=5u as=1.125p ps=5u w=9u l=7u
X166 a_53700_200# zn_m yn_m avss sg13_hv_nmos ad=1.125p pd=5u as=1.125p ps=5u w=9u l=1u
X167 yp_p in_m a_27300_1400# avss sg13_hv_nmos ad=1.125p pd=5u as=1.125p ps=5u w=9u l=1u
X168 a_30300_1400# bna xn avss sg13_hv_nmos ad=1.125p pd=5u as=1.125p ps=5u w=9u l=7u
X169 out zn_p a_56900_1400# avss sg13_hv_nmos ad=1.125p pd=5u as=1.125p ps=5u w=9u l=1u
X170 avdd zp_m yp_m avdd sg13_hv_pmos ad=1.125p pd=5u as=1.125p ps=5u w=9u l=7u
X171 out zp_p a_57100_6200# avdd sg13_hv_pmos ad=1.125p pd=5u as=1.125p ps=5u w=9u l=1u
X172 avss zn_m a_55100_200# avss sg13_hv_nmos ad=1.125p pd=5u as=1.125p ps=5u w=9u l=7u
X173 avdd en bpa avdd sg13_hv_pmos ad=1.125p pd=5u as=1.125p ps=5u w=9u l=3u
X174 a_43900_200# zn_m avss avss sg13_hv_nmos ad=1.125p pd=5u as=1.125p ps=5u w=9u l=7u
X175 a_12700_1400# bna avss avss sg13_hv_nmos ad=1.125p pd=5u as=1.125p ps=5u w=9u l=7u
X176 yn_m in_p xp avdd sg13_hv_pmos ad=1.125p pd=5u as=1.125p ps=5u w=9u l=1u
X177 a_17300_1400# bnb bnb avss sg13_hv_nmos ad=1.125p pd=5u as=1.125p ps=5u w=9u l=1u
X178 zn_p bpb zp_p avdd sg13_hv_pmos ad=1.125p pd=5u as=1.125p ps=5u w=9u l=1u
X179 a_22900_200# bnb bnb avss sg13_hv_nmos ad=1.125p pd=5u as=1.125p ps=5u w=9u l=1u
X180 bpb bpb bpa_l avdd sg13_hv_pmos ad=1.125p pd=5u as=1.125p ps=5u w=9u l=1u
X181 a_22500_1400# bnb bna_ avss sg13_hv_nmos ad=1.125p pd=5u as=1.125p ps=5u w=9u l=1u
X182 xp in_m yn_p avdd sg13_hv_pmos ad=1.125p pd=5u as=1.125p ps=5u w=9u l=1u
X183 avss bna_ a_24500_1400# avss sg13_hv_nmos ad=1.125p pd=5u as=1.125p ps=5u w=9u l=1u
X184 a_52100_1400# bnb zp_p avss sg13_hv_nmos ad=1.125p pd=5u as=1.125p ps=5u w=9u l=1u
X185 avdd bpa_l a_16500_5000# avdd sg13_hv_pmos ad=1.125p pd=5u as=1.125p ps=5u w=9u l=1u
X186 a_20100_200# bnb bna_ avss sg13_hv_nmos ad=1.125p pd=5u as=1.125p ps=5u w=9u l=1u
X187 a_57300_1400# zn_p out avss sg13_hv_nmos ad=1.125p pd=5u as=1.125p ps=5u w=9u l=1u
X188 a_57300_200# zn_p out avss sg13_hv_nmos ad=1.125p pd=5u as=1.125p ps=5u w=9u l=1u
X189 a_46100_1400# zn_m zn_m avss sg13_hv_nmos ad=1.125p pd=5u as=1.125p ps=5u w=9u l=1u
X190 bpa bpa avdd avdd sg13_hv_pmos ad=1.125p pd=5u as=1.125p ps=5u w=9u l=7u
X191 bna_ bnb a_17300_1400# avss sg13_hv_nmos ad=1.125p pd=5u as=1.125p ps=5u w=9u l=1u
X192 zn_m bpb a_46700_5000# avdd sg13_hv_pmos ad=1.125p pd=5u as=1.125p ps=5u w=9u l=1u
X193 yn_m in_p xp avdd sg13_hv_pmos ad=1.125p pd=5u as=1.125p ps=5u w=9u l=1u
X194 zp_m zp_m yp_p avdd sg13_hv_pmos ad=1.125p pd=5u as=1.125p ps=5u w=9u l=1u
X195 a_25500_200# bna avss avss sg13_hv_nmos ad=1.125p pd=5u as=1.125p ps=5u w=9u l=7u
X196 a_19700_1400# bnb bnb avss sg13_hv_nmos ad=1.125p pd=5u as=1.125p ps=5u w=9u l=1u
X197 zn_p bpb zp_p avdd sg13_hv_pmos ad=1.125p pd=5u as=1.125p ps=5u w=9u l=1u
X198 a_56300_6200# zp_p out avdd sg13_hv_pmos ad=1.125p pd=5u as=1.125p ps=5u w=9u l=1u
X199 a_46900_200# zn_m zn_m avss sg13_hv_nmos ad=1.125p pd=5u as=1.125p ps=5u w=9u l=1u
X200 a_25500_1400# bna avss avss sg13_hv_nmos ad=1.125p pd=5u as=1.125p ps=5u w=9u l=7u
X201 zn_p bnb a_52100_1400# avss sg13_hv_nmos ad=1.125p pd=5u as=1.125p ps=5u w=9u l=1u
X202 a_22100_200# bnb bnb avss sg13_hv_nmos ad=1.125p pd=5u as=1.125p ps=5u w=9u l=1u
X203 zp_m bnb a_40900_1400# avss sg13_hv_nmos ad=1.125p pd=5u as=1.125p ps=5u w=9u l=1u
X204 xp in_p yn_m avdd sg13_hv_pmos ad=1.125p pd=5u as=1.125p ps=5u w=9u l=1u
X205 avdd bpa a_46700_5000# avdd sg13_hv_pmos ad=1.125p pd=5u as=1.125p ps=5u w=9u l=7u
X206 a_26500_200# in_m xn avss sg13_hv_nmos ad=1.125p pd=5u as=1.125p ps=5u w=9u l=1u
X207 avss zn_p a_57300_1400# avss sg13_hv_nmos ad=1.125p pd=5u as=1.125p ps=5u w=9u l=1u
X208 avss bna a_7100_1400# avss sg13_hv_nmos ad=1.125p pd=5u as=1.125p ps=5u w=9u l=7u
X209 out zp_p avdd avdd sg13_hv_pmos ad=1.125p pd=5u as=1.125p ps=5u w=9u l=1u
X210 zn_p enb avss avss sg13_hv_nmos ad=1.125p pd=5u as=1.125p ps=5u w=9u l=3u
X211 avss enb zn_p avss sg13_hv_nmos ad=2.25p pd=10u as=1.125p ps=5u w=9u l=3u
X212 yn_p zn_m a_46100_1400# avss sg13_hv_nmos ad=1.125p pd=5u as=1.125p ps=5u w=9u l=1u
X213 zp_p zp_m yp_m avdd sg13_hv_pmos ad=1.125p pd=5u as=1.125p ps=5u w=9u l=1u
X214 bpa_r bpb bpb avdd sg13_hv_pmos ad=1.125p pd=5u as=1.125p ps=5u w=9u l=1u
X215 bpa_l bpb bpb avdd sg13_hv_pmos ad=1.125p pd=5u as=1.125p ps=5u w=9u l=1u
X216 yn_p in_m xp avdd sg13_hv_pmos ad=1.125p pd=5u as=1.125p ps=5u w=9u l=1u
X217 a_21300_5000# bpa_r a_21100_5000# avdd sg13_hv_pmos ad=1.125p pd=5u as=1.125p ps=5u w=9u l=1u
X218 avdd en zp_p avdd sg13_hv_pmos ad=2.25p pd=10u as=1.125p ps=5u w=9u l=3u
X219 bpb bpb bpa_l avdd sg13_hv_pmos ad=1.125p pd=5u as=1.125p ps=5u w=9u l=1u
X220 bna_ bnb a_19700_1400# avss sg13_hv_nmos ad=1.125p pd=5u as=1.125p ps=5u w=9u l=1u
X221 zp_p bpb zn_p avdd sg13_hv_pmos ad=1.125p pd=5u as=1.125p ps=5u w=9u l=1u
X222 a_49500_200# zn_m avss avss sg13_hv_nmos ad=1.125p pd=5u as=1.125p ps=5u w=9u l=7u
X223 a_36700_1400# zn_m yn_m avss sg13_hv_nmos ad=1.125p pd=5u as=1.125p ps=5u w=9u l=7u
X224 zn_m bpb a_43900_5000# avdd sg13_hv_pmos ad=1.125p pd=5u as=1.125p ps=5u w=9u l=1u
X225 a_15900_200# bna_ a_15700_200# avss sg13_hv_nmos ad=1.125p pd=5u as=1.125p ps=5u w=9u l=1u
X226 a_52500_1400# bnb zn_p avss sg13_hv_nmos ad=1.125p pd=5u as=1.125p ps=5u w=9u l=1u
X227 yn_p in_m xp avdd sg13_hv_pmos ad=1.125p pd=5u as=1.125p ps=5u w=9u l=1u
X228 zp_m zp_m yp_p avdd sg13_hv_pmos ad=1.125p pd=5u as=1.125p ps=5u w=9u l=1u
X229 a_28500_200# in_p yp_m avss sg13_hv_nmos ad=1.125p pd=5u as=1.125p ps=5u w=9u l=1u
X230 a_24100_200# bna_ a_23900_200# avss sg13_hv_nmos ad=1.125p pd=5u as=1.125p ps=5u w=9u l=1u
X231 a_41300_1400# bnb zp_m avss sg13_hv_nmos ad=1.125p pd=5u as=1.125p ps=5u w=9u l=1u
X232 a_46100_200# zn_m zn_m avss sg13_hv_nmos ad=1.125p pd=5u as=1.125p ps=5u w=9u l=1u
X233 a_46500_1400# zn_m yn_p avss sg13_hv_nmos ad=1.125p pd=5u as=1.125p ps=5u w=9u l=1u
X234 bpa bna a_9500_1400# avss sg13_hv_nmos ad=1.125p pd=5u as=1.125p ps=5u w=9u l=7u
X235 enb en avdd avdd sg13_hv_pmos ad=1.125p pd=5u as=2.25p ps=10u w=9u l=3u
X236 avdd zp_m yp_m avdd sg13_hv_pmos ad=1.125p pd=5u as=1.125p ps=5u w=9u l=7u
X237 bpa_r bpb bpb avdd sg13_hv_pmos ad=1.125p pd=5u as=1.125p ps=5u w=9u l=1u
X238 xn bna a_25500_200# avss sg13_hv_nmos ad=1.125p pd=5u as=1.125p ps=5u w=9u l=7u
X239 a_46700_5000# bpb zn_m avdd sg13_hv_pmos ad=1.125p pd=5u as=1.125p ps=5u w=9u l=1u
X240 enb en avss avss sg13_hv_nmos ad=1.125p pd=5u as=2.25p ps=10u w=9u l=3u
X241 avdd zp_p out avdd sg13_hv_pmos ad=1.125p pd=5u as=1.125p ps=5u w=9u l=1u
X242 bpb bpb bpa_r avdd sg13_hv_pmos ad=1.125p pd=5u as=1.125p ps=5u w=9u l=1u
X243 bnb bnb a_17700_200# avss sg13_hv_nmos ad=1.125p pd=5u as=1.125p ps=5u w=9u l=1u
X244 bpb bpb bpa_l avdd sg13_hv_pmos ad=1.125p pd=5u as=1.125p ps=5u w=9u l=1u
X245 a_39100_200# bnb a_41300_1400# avss sg13_hv_nmos ad=1.125p pd=5u as=1.125p ps=5u w=9u l=1u
X246 zn_m bpb a_43900_5000# avdd sg13_hv_pmos ad=1.125p pd=5u as=1.125p ps=5u w=9u l=1u
X247 zp_p zp_m yp_m avdd sg13_hv_pmos ad=1.125p pd=5u as=1.125p ps=5u w=9u l=1u
X248 bpa_r bpb bpb avdd sg13_hv_pmos ad=1.125p pd=5u as=1.125p ps=5u w=9u l=1u
X249 avss zn_m a_47900_200# avss sg13_hv_nmos ad=1.125p pd=5u as=1.125p ps=5u w=9u l=7u
X250 a_58700_6200# zp_p out avdd sg13_hv_pmos ad=1.125p pd=5u as=1.125p ps=5u w=9u l=1u
X251 a_49500_1400# zn_m avss avss sg13_hv_nmos ad=1.125p pd=5u as=1.125p ps=5u w=9u l=7u
X252 a_27700_200# in_m yp_p avss sg13_hv_nmos ad=1.125p pd=5u as=1.125p ps=5u w=9u l=1u
X253 zn_p bnb a_52100_200# avss sg13_hv_nmos ad=1.125p pd=5u as=1.125p ps=5u w=9u l=1u
X254 xp in_m yn_p avdd sg13_hv_pmos ad=1.125p pd=5u as=1.125p ps=5u w=9u l=1u
X255 a_21100_6200# bpa_r a_20900_6200# avdd sg13_hv_pmos ad=1.125p pd=5u as=1.125p ps=5u w=9u l=1u
X256 a_31900_1400# zn_m avss avss sg13_hv_nmos ad=1.125p pd=5u as=1.125p ps=5u w=9u l=7u
X257 avss bna a_7100_200# avss sg13_hv_nmos ad=1.125p pd=5u as=1.125p ps=5u w=9u l=7u
X258 avdd bpa a_43900_5000# avdd sg13_hv_pmos ad=1.125p pd=5u as=1.125p ps=5u w=9u l=7u
X259 bna_ bnb a_19700_200# avss sg13_hv_nmos ad=1.125p pd=5u as=1.125p ps=5u w=9u l=1u
X260 bpb bpb bpa_r avdd sg13_hv_pmos ad=1.125p pd=5u as=1.125p ps=5u w=9u l=1u
X261 bnb bnb a_20900_1400# avss sg13_hv_nmos ad=1.125p pd=5u as=1.125p ps=5u w=9u l=1u
X262 a_46700_5000# bpa avdd avdd sg13_hv_pmos ad=1.125p pd=5u as=1.125p ps=5u w=9u l=7u
X263 bnb bnb a_16900_200# avss sg13_hv_nmos ad=1.125p pd=5u as=1.125p ps=5u w=9u l=1u
X264 bna_ bnb a_21300_200# avss sg13_hv_nmos ad=1.125p pd=5u as=1.125p ps=5u w=9u l=1u
X265 out zp_p avdd avdd sg13_hv_pmos ad=1.125p pd=5u as=1.125p ps=5u w=9u l=1u
X266 a_30300_200# bna xn avss sg13_hv_nmos ad=1.125p pd=5u as=1.125p ps=5u w=9u l=7u
X267 zp_p zp_m yp_m avdd sg13_hv_pmos ad=1.125p pd=5u as=1.125p ps=5u w=9u l=1u
X268 bpa_r bpa_r a_17300_6200# avdd sg13_hv_pmos ad=1.125p pd=5u as=1.125p ps=5u w=9u l=1u
X269 yn_m zn_m a_54100_200# avss sg13_hv_nmos ad=1.125p pd=5u as=1.125p ps=5u w=9u l=1u
X270 avdd bpa yp_m avdd sg13_hv_pmos ad=1.125p pd=5u as=1.125p ps=5u w=9u l=7u
X271 avss zn_m a_33500_1400# avss sg13_hv_nmos ad=1.125p pd=5u as=1.125p ps=5u w=9u l=7u
X272 out zp_p avdd avdd sg13_hv_pmos ad=1.125p pd=5u as=1.125p ps=5u w=9u l=1u
X273 a_31900_200# zn_m avss avss sg13_hv_nmos ad=1.125p pd=5u as=1.125p ps=5u w=9u l=7u
X274 bpa bpa avdd avdd sg13_hv_pmos ad=1.125p pd=5u as=1.125p ps=5u w=9u l=7u
X275 bpb bpb bpa_l avdd sg13_hv_pmos ad=1.125p pd=5u as=1.125p ps=5u w=9u l=1u
X276 a_16100_1400# bna_ a_15900_1400# avss sg13_hv_nmos ad=1.125p pd=5u as=1.125p ps=5u w=9u l=1u
X277 avdd zp_m yp_p avdd sg13_hv_pmos ad=1.125p pd=5u as=1.125p ps=5u w=9u l=7u
X278 xp bpa avdd avdd sg13_hv_pmos ad=1.125p pd=5u as=1.125p ps=5u w=9u l=7u
X279 avdd bpa xp avdd sg13_hv_pmos ad=1.125p pd=5u as=1.125p ps=5u w=9u l=7u
X280 bpb bpb bpa_r avdd sg13_hv_pmos ad=1.125p pd=5u as=1.125p ps=5u w=9u l=1u
X281 avdd zp_m yp_p avdd sg13_hv_pmos ad=1.125p pd=5u as=1.125p ps=5u w=9u l=7u
X282 bna_ bnb a_18900_200# avss sg13_hv_nmos ad=1.125p pd=5u as=1.125p ps=5u w=9u l=1u
X283 a_21300_1400# bnb bnb avss sg13_hv_nmos ad=1.125p pd=5u as=1.125p ps=5u w=9u l=1u
X284 a_23500_200# bna_ a_23300_200# avss sg13_hv_nmos ad=1.125p pd=5u as=1.125p ps=5u w=9u l=1u
X285 yp_m zp_m zp_p avdd sg13_hv_pmos ad=1.125p pd=5u as=1.125p ps=5u w=9u l=1u
X286 zp_m bnb a_40900_200# avss sg13_hv_nmos ad=1.125p pd=5u as=1.125p ps=5u w=9u l=1u
X287 avdd bpa bpa avdd sg13_hv_pmos ad=1.125p pd=5u as=1.125p ps=5u w=9u l=7u
X288 yn_p zn_m a_45300_200# avss sg13_hv_nmos ad=1.125p pd=5u as=1.125p ps=5u w=9u l=1u
X289 a_26500_1400# in_m xn avss sg13_hv_nmos ad=1.125p pd=5u as=1.125p ps=5u w=9u l=1u
X290 xn in_p a_28500_1400# avss sg13_hv_nmos ad=1.125p pd=5u as=1.125p ps=5u w=9u l=1u
X291 yp_p zp_m zp_m avdd sg13_hv_pmos ad=1.125p pd=5u as=1.125p ps=5u w=9u l=1u
X292 a_56100_1400# zn_p avss avss sg13_hv_nmos ad=1.125p pd=5u as=1.125p ps=5u w=9u l=1u
X293 a_17100_5000# bpa_r a_16900_5000# avdd sg13_hv_pmos ad=1.125p pd=5u as=1.125p ps=5u w=9u l=1u
X294 bna_ bnb a_20500_200# avss sg13_hv_nmos ad=1.125p pd=5u as=1.125p ps=5u w=9u l=1u
X295 a_43900_5000# bpb zn_m avdd sg13_hv_pmos ad=1.125p pd=5u as=1.125p ps=5u w=9u l=1u
X296 out zn_p a_57700_200# avss sg13_hv_nmos ad=1.125p pd=5u as=1.125p ps=5u w=9u l=1u
X297 a_16300_1400# bna_ a_16100_1400# avss sg13_hv_nmos ad=1.125p pd=5u as=1.125p ps=5u w=9u l=1u
X298 zn_p bpb zp_p avdd sg13_hv_pmos ad=1.125p pd=5u as=1.125p ps=5u w=9u l=1u
X299 a_16500_6200# bpa_l a_16300_6200# avdd sg13_hv_pmos ad=1.125p pd=5u as=1.125p ps=5u w=9u l=1u
X300 bpb bna a_12700_200# avss sg13_hv_nmos ad=1.125p pd=5u as=1.125p ps=5u w=9u l=7u
X301 bna_ bnb a_21300_1400# avss sg13_hv_nmos ad=1.125p pd=5u as=1.125p ps=5u w=9u l=1u
X302 zp_m zp_m yp_p avdd sg13_hv_pmos ad=1.125p pd=5u as=1.125p ps=5u w=9u l=1u
X303 zn_m bpb a_46700_5000# avdd sg13_hv_pmos ad=1.125p pd=5u as=1.125p ps=5u w=9u l=1u
X304 a_23700_1400# bna_ a_23500_1400# avss sg13_hv_nmos ad=1.125p pd=5u as=1.125p ps=5u w=9u l=1u
X305 avdd zp_p out avdd sg13_hv_pmos ad=1.125p pd=5u as=1.125p ps=5u w=9u l=1u
X306 yn_m zn_m a_50900_1400# avss sg13_hv_nmos ad=1.125p pd=5u as=1.125p ps=5u w=9u l=1u
X307 yp_m zp_m zp_p avdd sg13_hv_pmos ad=1.125p pd=5u as=1.125p ps=5u w=9u l=1u
X308 bpa_l bpb bpb avdd sg13_hv_pmos ad=1.125p pd=5u as=1.125p ps=5u w=9u l=1u
X309 a_28900_1400# in_p xn avss sg13_hv_nmos ad=1.125p pd=5u as=1.125p ps=5u w=9u l=1u
X310 out zn_p a_56100_1400# avss sg13_hv_nmos ad=1.125p pd=5u as=1.125p ps=5u w=9u l=1u
X311 bna en ib avss sg13_hv_nmos ad=1.125p pd=5u as=1.125p ps=5u w=9u l=3u
X312 yp_p zp_m zp_m avdd sg13_hv_pmos ad=1.125p pd=5u as=1.125p ps=5u w=9u l=1u
X313 bnb bnb a_22500_200# avss sg13_hv_nmos ad=1.125p pd=5u as=1.125p ps=5u w=9u l=1u
X314 zn_m zn_m a_44900_1400# avss sg13_hv_nmos ad=1.125p pd=5u as=1.125p ps=5u w=9u l=1u
X315 xp in_p yn_m avdd sg13_hv_pmos ad=1.125p pd=5u as=1.125p ps=5u w=9u l=1u
X316 bna bna a_4700_1400# avss sg13_hv_nmos ad=1.125p pd=5u as=1.125p ps=5u w=9u l=7u
X317 avss bna a_11100_1400# avss sg13_hv_nmos ad=1.125p pd=5u as=1.125p ps=5u w=9u l=7u
X318 zp_p en avdd avdd sg13_hv_pmos ad=1.125p pd=5u as=1.125p ps=5u w=9u l=3u
X319 zp_p zp_m yp_m avdd sg13_hv_pmos ad=1.125p pd=5u as=1.125p ps=5u w=9u l=1u
X320 bpa_l bpb bpb avdd sg13_hv_pmos ad=1.125p pd=5u as=1.125p ps=5u w=9u l=1u
X321 bpa_r bpb bpb avdd sg13_hv_pmos ad=1.125p pd=5u as=1.125p ps=5u w=9u l=1u
X322 a_16500_1400# bna_ a_16300_1400# avss sg13_hv_nmos ad=1.125p pd=5u as=1.125p ps=5u w=9u l=1u
X323 zp_m zp_m yp_p avdd sg13_hv_pmos ad=1.125p pd=5u as=1.125p ps=5u w=9u l=1u
X324 bnb bnb a_18500_1400# avss sg13_hv_nmos ad=1.125p pd=5u as=1.125p ps=5u w=9u l=1u
X325 avdd zp_m yp_p avdd sg13_hv_pmos ad=1.125p pd=5u as=1.125p ps=5u w=9u l=7u
X326 yn_p in_m xp avdd sg13_hv_pmos ad=1.125p pd=5u as=1.125p ps=5u w=9u l=1u
X327 a_16100_5000# bpa_l bpa_l avdd sg13_hv_pmos ad=1.125p pd=5u as=1.125p ps=5u w=9u l=1u
X328 bnb bpa avdd avdd sg13_hv_pmos ad=1.125p pd=5u as=1.125p ps=5u w=9u l=7u
X329 avss zn_m a_36700_200# avss sg13_hv_nmos ad=1.125p pd=5u as=1.125p ps=5u w=9u l=7u
X330 out zn_p a_56900_200# avss sg13_hv_nmos ad=1.125p pd=5u as=1.125p ps=5u w=9u l=1u
X331 a_23900_1400# bna_ a_23700_1400# avss sg13_hv_nmos ad=1.125p pd=5u as=1.125p ps=5u w=9u l=1u
X332 a_51300_1400# zn_m yn_m avss sg13_hv_nmos ad=1.125p pd=5u as=1.125p ps=5u w=9u l=1u
X333 a_12700_200# bna avss avss sg13_hv_nmos ad=1.125p pd=5u as=1.125p ps=5u w=9u l=7u
X334 a_16500_200# bna_ a_16300_200# avss sg13_hv_nmos ad=1.125p pd=5u as=1.125p ps=5u w=9u l=1u
X335 a_40100_1400# bnb a_39100_200# avss sg13_hv_nmos ad=1.125p pd=5u as=1.125p ps=5u w=9u l=1u
X336 zp_m zp_m yp_p avdd sg13_hv_pmos ad=1.125p pd=5u as=1.125p ps=5u w=9u l=1u
X337 zn_m bpb a_43900_5000# avdd sg13_hv_pmos ad=1.125p pd=5u as=1.125p ps=5u w=9u l=1u
X338 a_56500_1400# zn_p out avss sg13_hv_nmos ad=1.125p pd=5u as=1.125p ps=5u w=9u l=1u
X339 bpa_l bpb bpb avdd sg13_hv_pmos ad=1.125p pd=5u as=1.125p ps=5u w=9u l=1u
X340 yp_m zp_m avdd avdd sg13_hv_pmos ad=1.125p pd=5u as=1.125p ps=5u w=9u l=7u
X341 avdd bpa xp avdd sg13_hv_pmos ad=1.125p pd=5u as=1.125p ps=5u w=9u l=7u
X342 avss bna_ a_24500_200# avss sg13_hv_nmos ad=1.125p pd=5u as=1.125p ps=5u w=9u l=1u
X343 a_45300_1400# zn_m zn_m avss sg13_hv_nmos ad=1.125p pd=5u as=1.125p ps=5u w=9u l=1u
X344 out zn_p a_58500_1400# avss sg13_hv_nmos ad=1.125p pd=5u as=1.125p ps=5u w=9u l=1u
X345 zn_m zn_m a_46500_200# avss sg13_hv_nmos ad=1.125p pd=5u as=1.125p ps=5u w=9u l=1u
X346 a_14300_1400# bna bpb avss sg13_hv_nmos ad=1.125p pd=5u as=1.125p ps=5u w=9u l=7u
X347 avdd en enb avdd sg13_hv_pmos ad=1.125p pd=5u as=1.125p ps=5u w=9u l=3u
X348 zp_p zp_m yp_m avdd sg13_hv_pmos ad=1.125p pd=5u as=1.125p ps=5u w=9u l=1u
X349 a_12500_5000# bpa_l a_12300_5000# avdd sg13_hv_pmos ad=1.125p pd=5u as=1.125p ps=5u w=9u l=1u
X350 a_50900_200# zn_m zn_p avss sg13_hv_nmos ad=1.125p pd=5u as=1.125p ps=5u w=9u l=1u
X351 a_18900_1400# bnb bnb avss sg13_hv_nmos ad=1.125p pd=5u as=1.125p ps=5u w=9u l=1u
X352 avss zn_p a_58900_200# avss sg13_hv_nmos ad=1.125p pd=5u as=1.125p ps=5u w=9u l=1u
X353 yp_p zp_m avdd avdd sg13_hv_pmos ad=1.125p pd=5u as=1.125p ps=5u w=9u l=7u
X354 zn_p zn_m a_51300_1400# avss sg13_hv_nmos ad=1.125p pd=5u as=1.125p ps=5u w=9u l=1u
X355 avdd zp_p out avdd sg13_hv_pmos ad=1.125p pd=5u as=1.125p ps=5u w=9u l=1u
X356 a_53700_1400# zn_m yn_m avss sg13_hv_nmos ad=1.125p pd=5u as=1.125p ps=5u w=9u l=1u
X357 zp_m bnb a_40100_1400# avss sg13_hv_nmos ad=1.125p pd=5u as=1.125p ps=5u w=9u l=1u
X358 bpb bpb bpa_l avdd sg13_hv_pmos ad=1.125p pd=5u as=1.125p ps=5u w=9u l=1u
X359 bpb bpb bpa_r avdd sg13_hv_pmos ad=1.125p pd=5u as=1.125p ps=5u w=9u l=1u
X360 a_36700_200# zn_m yn_m avss sg13_hv_nmos ad=1.125p pd=5u as=1.125p ps=5u w=9u l=7u
X361 a_18500_200# bnb bna_ avss sg13_hv_nmos ad=1.125p pd=5u as=1.125p ps=5u w=9u l=1u
X362 a_40500_200# bnb zp_m avss sg13_hv_nmos ad=1.125p pd=5u as=1.125p ps=5u w=9u l=1u
X363 a_7100_1400# bna bna avss sg13_hv_nmos ad=1.125p pd=5u as=1.125p ps=5u w=9u l=7u
X364 a_58900_1400# zn_p out avss sg13_hv_nmos ad=1.125p pd=5u as=1.125p ps=5u w=9u l=1u
X365 yn_p zn_m a_45300_1400# avss sg13_hv_nmos ad=1.125p pd=5u as=1.125p ps=5u w=9u l=1u
X366 bpa_l bpb bpb avdd sg13_hv_pmos ad=1.125p pd=5u as=1.125p ps=5u w=9u l=1u
X367 bpa_r bpb bpb avdd sg13_hv_pmos ad=1.125p pd=5u as=1.125p ps=5u w=9u l=1u
X368 avdd zp_p out avdd sg13_hv_pmos ad=1.125p pd=5u as=1.125p ps=5u w=9u l=1u
X369 a_15700_200# bna_ a_15500_200# avss sg13_hv_nmos ad=1.125p pd=5u as=1.125p ps=5u w=9u l=1u
X370 yp_m in_p a_28100_200# avss sg13_hv_nmos ad=1.125p pd=5u as=1.125p ps=5u w=9u l=1u
X371 a_52900_200# bnb zp_p avss sg13_hv_nmos ad=1.125p pd=5u as=1.125p ps=5u w=9u l=1u
X372 xp in_m yn_p avdd sg13_hv_pmos ad=1.125p pd=5u as=1.125p ps=5u w=9u l=1u
X373 yn_m zn_m a_35100_1400# avss sg13_hv_nmos ad=1.125p pd=5u as=1.125p ps=5u w=9u l=7u
X374 zn_p zn_m a_53700_1400# avss sg13_hv_nmos ad=1.125p pd=5u as=1.125p ps=5u w=9u l=1u
X375 a_40500_1400# bnb zp_m avss sg13_hv_nmos ad=1.125p pd=5u as=1.125p ps=5u w=9u l=1u
X376 yp_m zp_m avdd avdd sg13_hv_pmos ad=1.125p pd=5u as=1.125p ps=5u w=9u l=7u
X377 avss bna a_42300_200# avss sg13_hv_nmos ad=1.125p pd=5u as=1.125p ps=5u w=9u l=7u
X378 a_9500_1400# bna avss avss sg13_hv_nmos ad=1.125p pd=5u as=1.125p ps=5u w=9u l=7u
X379 avdd bpa bnb avdd sg13_hv_pmos ad=1.125p pd=5u as=1.125p ps=5u w=9u l=7u
X380 a_17700_200# bnb bna_ avss sg13_hv_nmos ad=1.125p pd=5u as=1.125p ps=5u w=9u l=1u
X381 out zp_p avdd avdd sg13_hv_pmos ad=1.125p pd=5u as=1.125p ps=5u w=9u l=1u
X382 avdd zp_m yp_m avdd sg13_hv_pmos ad=1.125p pd=5u as=1.125p ps=5u w=9u l=7u
X383 a_12300_6200# bpa_l a_12100_6200# avdd sg13_hv_pmos ad=1.125p pd=5u as=1.125p ps=5u w=9u l=1u
X384 bpa_r bpb bpb avdd sg13_hv_pmos ad=1.125p pd=5u as=1.125p ps=5u w=9u l=1u
X385 yn_m in_p xp avdd sg13_hv_pmos ad=1.125p pd=5u as=1.125p ps=5u w=9u l=1u
X386 a_38300_1400# bna avss avss sg13_hv_nmos ad=1.125p pd=5u as=1.125p ps=5u w=9u l=7u
X387 a_52100_200# bnb zp_p avss sg13_hv_nmos ad=1.125p pd=5u as=1.125p ps=5u w=9u l=1u
X388 out zp_p a_57900_6200# avdd sg13_hv_pmos ad=1.125p pd=5u as=1.125p ps=5u w=9u l=1u
X389 a_56500_200# zn_p out avss sg13_hv_nmos ad=1.125p pd=5u as=1.125p ps=5u w=9u l=1u
X390 bpb bpb bpa_l avdd sg13_hv_pmos ad=1.125p pd=5u as=1.125p ps=5u w=9u l=1u
X391 a_20100_1400# bnb bna_ avss sg13_hv_nmos ad=1.125p pd=5u as=1.125p ps=5u w=9u l=1u
X392 a_19700_200# bnb bnb avss sg13_hv_nmos ad=1.125p pd=5u as=1.125p ps=5u w=9u l=1u
X393 a_42300_200# bna a_39100_200# avss sg13_hv_nmos ad=1.125p pd=5u as=1.125p ps=5u w=9u l=7u
X394 avss bna a_30300_1400# avss sg13_hv_nmos ad=1.125p pd=5u as=1.125p ps=5u w=9u l=7u
X395 bpa bpa avdd avdd sg13_hv_pmos ad=1.125p pd=5u as=1.125p ps=5u w=9u l=7u
X396 a_21300_200# bnb bnb avss sg13_hv_nmos ad=1.125p pd=5u as=1.125p ps=5u w=9u l=1u
X397 zp_p bpb zn_p avdd sg13_hv_pmos ad=1.125p pd=5u as=1.125p ps=5u w=9u l=1u
X398 a_54100_200# zn_m zn_p avss sg13_hv_nmos ad=1.125p pd=5u as=1.125p ps=5u w=9u l=1u
X399 a_58500_200# zn_p avss avss sg13_hv_nmos ad=1.125p pd=5u as=1.125p ps=5u w=9u l=1u
X400 avdd zp_p out avdd sg13_hv_pmos ad=1.125p pd=5u as=1.125p ps=5u w=9u l=1u
X401 zn_p bpb zp_p avdd sg13_hv_pmos ad=1.125p pd=5u as=1.125p ps=5u w=9u l=1u
X402 avdd bpa bnb avdd sg13_hv_pmos ad=1.125p pd=5u as=1.125p ps=5u w=9u l=7u
X403 bnb bnb a_20100_1400# avss sg13_hv_nmos ad=1.125p pd=5u as=1.125p ps=5u w=9u l=1u
X404 avdd bpa bpa avdd sg13_hv_pmos ad=1.125p pd=5u as=1.125p ps=5u w=9u l=7u
X405 a_16900_6200# bpa_r avdd avdd sg13_hv_pmos ad=1.125p pd=5u as=1.125p ps=5u w=9u l=1u
X406 xp in_p yn_m avdd sg13_hv_pmos ad=1.125p pd=5u as=1.125p ps=5u w=9u l=1u
X407 avdd bpa a_46700_5000# avdd sg13_hv_pmos ad=1.125p pd=5u as=1.125p ps=5u w=9u l=7u
X408 a_27700_1400# in_m yp_p avss sg13_hv_nmos ad=1.125p pd=5u as=1.125p ps=5u w=9u l=1u
X409 a_57100_6200# zp_p out avdd sg13_hv_pmos ad=1.125p pd=5u as=1.125p ps=5u w=9u l=1u
X410 bpa_l bpb bpb avdd sg13_hv_pmos ad=1.125p pd=5u as=1.125p ps=5u w=9u l=1u
X411 bpa_r bpb bpb avdd sg13_hv_pmos ad=1.125p pd=5u as=1.125p ps=5u w=9u l=1u
X412 a_33500_1400# zn_m yn_p avss sg13_hv_nmos ad=1.125p pd=5u as=1.125p ps=5u w=9u l=7u
X413 avss en enb avss sg13_hv_nmos ad=1.125p pd=5u as=1.125p ps=5u w=9u l=3u
X414 a_46700_5000# bpb zn_m avdd sg13_hv_pmos ad=1.125p pd=5u as=1.125p ps=5u w=9u l=1u
X415 a_23300_200# bna_ bna_ avss sg13_hv_nmos ad=1.125p pd=5u as=1.125p ps=5u w=9u l=1u
X416 xp in_p yn_m avdd sg13_hv_pmos ad=1.125p pd=5u as=1.125p ps=5u w=9u l=1u
X417 yp_p zp_m zp_m avdd sg13_hv_pmos ad=1.125p pd=5u as=1.125p ps=5u w=9u l=1u
X418 a_45300_200# zn_m zn_m avss sg13_hv_nmos ad=1.125p pd=5u as=1.125p ps=5u w=9u l=1u
X419 a_15300_1400# bna_ avss avss sg13_hv_nmos ad=1.125p pd=5u as=1.125p ps=5u w=9u l=1u
X420 avdd en zp_p avdd sg13_hv_pmos ad=2.25p pd=10u as=1.125p ps=5u w=9u l=3u
X421 zp_p bpb zn_p avdd sg13_hv_pmos ad=1.125p pd=5u as=1.125p ps=5u w=9u l=1u
X422 bpa_l bpb bpb avdd sg13_hv_pmos ad=1.125p pd=5u as=1.125p ps=5u w=9u l=1u
X423 a_20500_1400# bnb bnb avss sg13_hv_nmos ad=1.125p pd=5u as=1.125p ps=5u w=9u l=1u
X424 zp_m zp_m yp_p avdd sg13_hv_pmos ad=1.125p pd=5u as=1.125p ps=5u w=9u l=1u
X425 zn_m bpb a_43900_5000# avdd sg13_hv_pmos ad=1.125p pd=5u as=1.125p ps=5u w=9u l=1u
X426 bnb bnb a_22500_1400# avss sg13_hv_nmos ad=1.125p pd=5u as=1.125p ps=5u w=9u l=1u
X427 yn_p in_m xp avdd sg13_hv_pmos ad=1.125p pd=5u as=1.125p ps=5u w=9u l=1u
X428 a_57700_200# zn_p avss avss sg13_hv_nmos ad=1.125p pd=5u as=1.125p ps=5u w=9u l=1u
X429 yp_m zp_m zp_p avdd sg13_hv_pmos ad=1.125p pd=5u as=1.125p ps=5u w=9u l=1u
X430 xn in_m a_27700_1400# avss sg13_hv_nmos ad=1.125p pd=5u as=1.125p ps=5u w=9u l=1u
X431 avss zn_m a_55100_1400# avss sg13_hv_nmos ad=1.125p pd=5u as=1.125p ps=5u w=9u l=7u
X432 enb en avdd avdd sg13_hv_pmos ad=1.125p pd=5u as=2.25p ps=10u w=9u l=3u
X433 avdd zp_m yp_m avdd sg13_hv_pmos ad=1.125p pd=5u as=1.125p ps=5u w=9u l=7u
X434 avdd bpa_r a_21300_6200# avdd sg13_hv_pmos ad=1.125p pd=5u as=1.125p ps=5u w=9u l=1u
X435 avdd zp_m yp_p avdd sg13_hv_pmos ad=1.125p pd=5u as=1.125p ps=5u w=9u l=7u
X436 bpa_l bpb bpb avdd sg13_hv_pmos ad=1.125p pd=5u as=1.125p ps=5u w=9u l=1u
X437 a_47900_200# zn_m yn_p avss sg13_hv_nmos ad=1.125p pd=5u as=1.125p ps=5u w=9u l=7u
X438 a_15500_1400# bna_ a_15300_1400# avss sg13_hv_nmos ad=1.125p pd=5u as=1.125p ps=5u w=9u l=1u
X439 a_46700_5000# bpb zn_m avdd sg13_hv_pmos ad=1.125p pd=5u as=1.125p ps=5u w=9u l=1u
X440 a_17700_1400# bnb bna_ avss sg13_hv_nmos ad=1.125p pd=5u as=1.125p ps=5u w=9u l=1u
X441 tihi tihi avdd avdd sg13_hv_pmos ad=1.125p pd=5u as=1.125p ps=5u w=9u l=19u
X442 out zp_p avdd avdd sg13_hv_pmos ad=1.125p pd=5u as=1.125p ps=5u w=9u l=1u
X443 zn_p zn_m a_51300_200# avss sg13_hv_nmos ad=1.125p pd=5u as=1.125p ps=5u w=9u l=1u
X444 a_26900_200# in_m yp_p avss sg13_hv_nmos ad=1.125p pd=5u as=1.125p ps=5u w=9u l=1u
X445 bpb bpb bpa_l avdd sg13_hv_pmos ad=1.125p pd=5u as=1.125p ps=5u w=9u l=1u
X446 bpb bpb bpa_r avdd sg13_hv_pmos ad=1.125p pd=5u as=1.125p ps=5u w=9u l=1u
X447 a_22900_1400# bnb bnb avss sg13_hv_nmos ad=1.125p pd=5u as=1.125p ps=5u w=9u l=1u
X448 zp_m bnb a_39300_200# avss sg13_hv_nmos ad=1.125p pd=5u as=1.125p ps=5u w=9u l=1u
X449 avss enb zn_p avss sg13_hv_nmos ad=2.25p pd=10u as=1.125p ps=5u w=9u l=3u
X450 yn_m in_p xp avdd sg13_hv_pmos ad=1.125p pd=5u as=1.125p ps=5u w=9u l=1u
X451 a_7100_200# bna bna avss sg13_hv_nmos ad=1.125p pd=5u as=1.125p ps=5u w=9u l=7u
X452 avdd zp_p out avdd sg13_hv_pmos ad=1.125p pd=5u as=1.125p ps=5u w=9u l=1u
X453 yp_p zp_m avdd avdd sg13_hv_pmos ad=1.125p pd=5u as=1.125p ps=5u w=9u l=7u
X454 a_57700_1400# zn_p avss avss sg13_hv_nmos ad=1.125p pd=5u as=1.125p ps=5u w=9u l=1u
X455 bpb bpb bpa_l avdd sg13_hv_pmos ad=1.125p pd=5u as=1.125p ps=5u w=9u l=1u
X456 bpb bpb bpa_r avdd sg13_hv_pmos ad=1.125p pd=5u as=1.125p ps=5u w=9u l=1u
X457 a_11100_1400# bna bpa avss sg13_hv_nmos ad=1.125p pd=5u as=1.125p ps=5u w=9u l=7u
X458 bpa en avdd avdd sg13_hv_pmos ad=1.125p pd=5u as=1.125p ps=5u w=9u l=3u
X459 a_21100_5000# bpa_r a_20900_5000# avdd sg13_hv_pmos ad=1.125p pd=5u as=1.125p ps=5u w=9u l=1u
X460 xp in_m yn_p avdd sg13_hv_pmos ad=1.125p pd=5u as=1.125p ps=5u w=9u l=1u
X461 yp_m zp_m avdd avdd sg13_hv_pmos ad=1.125p pd=5u as=1.125p ps=5u w=9u l=7u
X462 a_16300_200# bna_ a_16100_200# avss sg13_hv_nmos ad=1.125p pd=5u as=1.125p ps=5u w=9u l=1u
X463 bnb bnb a_17700_1400# avss sg13_hv_nmos ad=1.125p pd=5u as=1.125p ps=5u w=9u l=1u
X464 a_28900_200# in_p xn avss sg13_hv_nmos ad=1.125p pd=5u as=1.125p ps=5u w=9u l=1u
X465 yn_m zn_m a_53300_200# avss sg13_hv_nmos ad=1.125p pd=5u as=1.125p ps=5u w=9u l=1u
X466 yp_m zp_m zp_p avdd sg13_hv_pmos ad=1.125p pd=5u as=1.125p ps=5u w=9u l=1u
X467 bpb bpb bpa_r avdd sg13_hv_pmos ad=1.125p pd=5u as=1.125p ps=5u w=9u l=1u
X468 xp in_m yn_p avdd sg13_hv_pmos ad=1.125p pd=5u as=1.125p ps=5u w=9u l=1u
X469 yp_p zp_m zp_m avdd sg13_hv_pmos ad=1.125p pd=5u as=1.125p ps=5u w=9u l=1u
X470 a_43900_5000# bpb zn_m avdd sg13_hv_pmos ad=1.125p pd=5u as=1.125p ps=5u w=9u l=1u
X471 a_50500_1400# zn_m yn_m avss sg13_hv_nmos ad=1.125p pd=5u as=1.125p ps=5u w=9u l=1u
X472 zp_p bnb a_52500_1400# avss sg13_hv_nmos ad=1.125p pd=5u as=1.125p ps=5u w=9u l=1u
X473 avss enb bna avss sg13_hv_nmos ad=1.125p pd=5u as=1.125p ps=5u w=9u l=3u
X474 a_46700_5000# bpa avdd avdd sg13_hv_pmos ad=1.125p pd=5u as=1.125p ps=5u w=9u l=7u
X475 avss bna a_30300_200# avss sg13_hv_nmos ad=1.125p pd=5u as=1.125p ps=5u w=9u l=7u
X476 zn_p zn_m a_50500_200# avss sg13_hv_nmos ad=1.125p pd=5u as=1.125p ps=5u w=9u l=1u
X477 out zn_p a_57700_1400# avss sg13_hv_nmos ad=1.125p pd=5u as=1.125p ps=5u w=9u l=1u
X478 yp_m zp_m zp_p avdd sg13_hv_pmos ad=1.125p pd=5u as=1.125p ps=5u w=9u l=1u
X479 zn_m zn_m a_46500_1400# avss sg13_hv_nmos ad=1.125p pd=5u as=1.125p ps=5u w=9u l=1u
X480 bpa_r bpa_r a_17300_5000# avdd sg13_hv_pmos ad=1.125p pd=5u as=1.125p ps=5u w=9u l=1u
X481 ib en bna avss sg13_hv_nmos ad=1.125p pd=5u as=1.125p ps=5u w=9u l=3u
X482 avss en enb avss sg13_hv_nmos ad=1.125p pd=5u as=1.125p ps=5u w=9u l=3u
X483 bpb bna a_12700_1400# avss sg13_hv_nmos ad=1.125p pd=5u as=1.125p ps=5u w=9u l=7u
X484 bna_ bnb a_18100_200# avss sg13_hv_nmos ad=1.125p pd=5u as=1.125p ps=5u w=9u l=1u
X485 zp_m bnb a_40100_200# avss sg13_hv_nmos ad=1.125p pd=5u as=1.125p ps=5u w=9u l=1u
X486 out zp_p avdd avdd sg13_hv_pmos ad=1.125p pd=5u as=1.125p ps=5u w=9u l=1u
X487 bpa_l bpa_l a_12500_6200# avdd sg13_hv_pmos ad=1.125p pd=5u as=1.125p ps=5u w=9u l=1u
X488 bpa_r bpb bpb avdd sg13_hv_pmos ad=1.125p pd=5u as=1.125p ps=5u w=9u l=1u
X489 xp bpa avdd avdd sg13_hv_pmos ad=1.125p pd=5u as=1.125p ps=5u w=9u l=7u
X490 avdd bpa xp avdd sg13_hv_pmos ad=1.125p pd=5u as=1.125p ps=5u w=9u l=7u
X491 avdd zp_m yp_p avdd sg13_hv_pmos ad=1.125p pd=5u as=1.125p ps=5u w=9u l=7u
X492 a_52900_1400# bnb zp_p avss sg13_hv_nmos ad=1.125p pd=5u as=1.125p ps=5u w=9u l=1u
X493 bpb bpb bpa_r avdd sg13_hv_pmos ad=1.125p pd=5u as=1.125p ps=5u w=9u l=1u
X494 avdd zp_m yp_p avdd sg13_hv_pmos ad=1.125p pd=5u as=1.125p ps=5u w=9u l=7u
X495 a_28100_200# in_p xn avss sg13_hv_nmos ad=1.125p pd=5u as=1.125p ps=5u w=9u l=1u
X496 zp_p bnb a_52500_200# avss sg13_hv_nmos ad=1.125p pd=5u as=1.125p ps=5u w=9u l=1u
X497 a_42300_1400# bna a_39100_200# avss sg13_hv_nmos ad=1.125p pd=5u as=1.125p ps=5u w=9u l=7u
X498 yp_m zp_m zp_p avdd sg13_hv_pmos ad=1.125p pd=5u as=1.125p ps=5u w=9u l=1u
X499 avdd bpa bpa avdd sg13_hv_pmos ad=1.125p pd=5u as=1.125p ps=5u w=9u l=7u
X500 a_46900_1400# zn_m zn_m avss sg13_hv_nmos ad=1.125p pd=5u as=1.125p ps=5u w=9u l=1u
X501 yp_m zp_m avdd avdd sg13_hv_pmos ad=1.125p pd=5u as=1.125p ps=5u w=9u l=7u
X502 yn_p in_m xp avdd sg13_hv_pmos ad=1.125p pd=5u as=1.125p ps=5u w=9u l=1u
X503 yp_p zp_m avdd avdd sg13_hv_pmos ad=1.125p pd=5u as=1.125p ps=5u w=9u l=7u
X504 a_43900_5000# bpa avdd avdd sg13_hv_pmos ad=1.125p pd=5u as=1.125p ps=5u w=9u l=7u
X505 a_43900_5000# bpb zn_m avdd sg13_hv_pmos ad=1.125p pd=5u as=1.125p ps=5u w=9u l=1u
X506 a_16500_5000# bpa_l a_16300_5000# avdd sg13_hv_pmos ad=1.125p pd=5u as=1.125p ps=5u w=9u l=1u
X507 bnb bnb a_21700_200# avss sg13_hv_nmos ad=1.125p pd=5u as=1.125p ps=5u w=9u l=1u
X508 zp_p zp_m yp_m avdd sg13_hv_pmos ad=1.125p pd=5u as=1.125p ps=5u w=9u l=1u
X509 a_35100_200# zn_m avss avss sg13_hv_nmos ad=1.125p pd=5u as=1.125p ps=5u w=9u l=7u
X510 yn_p zn_m a_43900_1400# avss sg13_hv_nmos ad=1.125p pd=5u as=1.125p ps=5u w=9u l=7u
X511 avdd zp_p out avdd sg13_hv_pmos ad=1.125p pd=5u as=1.125p ps=5u w=9u l=1u
X512 yp_m zp_m zp_p avdd sg13_hv_pmos ad=1.125p pd=5u as=1.125p ps=5u w=9u l=1u
X513 bpa bna a_9500_200# avss sg13_hv_nmos ad=1.125p pd=5u as=1.125p ps=5u w=9u l=7u
X514 avdd tihi tihi avdd sg13_hv_pmos ad=1.125p pd=5u as=1.125p ps=5u w=9u l=19u
X515 a_17300_6200# bpa_r a_17100_6200# avdd sg13_hv_pmos ad=1.125p pd=5u as=1.125p ps=5u w=9u l=1u
X516 out zn_p a_56100_200# avss sg13_hv_nmos ad=1.125p pd=5u as=1.125p ps=5u w=9u l=1u
X517 xp in_p yn_m avdd sg13_hv_pmos ad=1.125p pd=5u as=1.125p ps=5u w=9u l=1u
X518 yp_p zp_m zp_m avdd sg13_hv_pmos ad=1.125p pd=5u as=1.125p ps=5u w=9u l=1u
X519 zp_p bpb zn_p avdd sg13_hv_pmos ad=1.125p pd=5u as=1.125p ps=5u w=9u l=1u
X520 bpa_r bpb bpb avdd sg13_hv_pmos ad=1.125p pd=5u as=1.125p ps=5u w=9u l=1u
X521 avss bna a_11100_200# avss sg13_hv_nmos ad=1.125p pd=5u as=1.125p ps=5u w=9u l=7u
X522 bpa_l bpb bpb avdd sg13_hv_pmos ad=1.125p pd=5u as=1.125p ps=5u w=9u l=1u
X523 avss zn_m a_36700_1400# avss sg13_hv_nmos ad=1.125p pd=5u as=1.125p ps=5u w=9u l=7u
X524 a_23900_200# bna_ a_23700_200# avss sg13_hv_nmos ad=1.125p pd=5u as=1.125p ps=5u w=9u l=1u
X525 a_46700_5000# bpb zn_m avdd sg13_hv_pmos ad=1.125p pd=5u as=1.125p ps=5u w=9u l=1u
X526 xp in_p yn_m avdd sg13_hv_pmos ad=1.125p pd=5u as=1.125p ps=5u w=9u l=1u
X527 yp_p zp_m zp_m avdd sg13_hv_pmos ad=1.125p pd=5u as=1.125p ps=5u w=9u l=1u
X528 zn_m zn_m a_45700_200# avss sg13_hv_nmos ad=1.125p pd=5u as=1.125p ps=5u w=9u l=1u
X529 bnb bnb a_20900_200# avss sg13_hv_nmos ad=1.125p pd=5u as=1.125p ps=5u w=9u l=1u
X530 zn_m bpb a_43900_5000# avdd sg13_hv_pmos ad=1.125p pd=5u as=1.125p ps=5u w=9u l=1u
X531 avdd bpa xp avdd sg13_hv_pmos ad=1.125p pd=5u as=1.125p ps=5u w=9u l=7u
X532 zp_m zp_m yp_p avdd sg13_hv_pmos ad=1.125p pd=5u as=1.125p ps=5u w=9u l=1u
X533 avss zn_m a_33500_200# avss sg13_hv_nmos ad=1.125p pd=5u as=1.125p ps=5u w=9u l=7u
X534 avss zn_p a_58100_200# avss sg13_hv_nmos ad=1.125p pd=5u as=1.125p ps=5u w=9u l=1u
X535 yp_p in_m a_26500_1400# avss sg13_hv_nmos ad=1.125p pd=5u as=1.125p ps=5u w=9u l=1u
X536 bpa_l bpb bpb avdd sg13_hv_pmos ad=1.125p pd=5u as=1.125p ps=5u w=9u l=1u
X537 yp_m zp_m avdd avdd sg13_hv_pmos ad=1.125p pd=5u as=1.125p ps=5u w=9u l=7u
X538 zn_p bpb zp_p avdd sg13_hv_pmos ad=1.125p pd=5u as=1.125p ps=5u w=9u l=1u
X539 avdd en enb avdd sg13_hv_pmos ad=1.125p pd=5u as=1.125p ps=5u w=9u l=3u
X540 yn_m zn_m a_35100_200# avss sg13_hv_nmos ad=1.125p pd=5u as=1.125p ps=5u w=9u l=7u
X541 zp_p zp_m yp_m avdd sg13_hv_pmos ad=1.125p pd=5u as=1.125p ps=5u w=9u l=1u
X542 a_39300_1400# bnb a_39100_200# avss sg13_hv_nmos ad=1.125p pd=5u as=1.125p ps=5u w=9u l=1u
X543 a_16300_6200# bpa_l a_16100_6200# avdd sg13_hv_pmos ad=1.125p pd=5u as=1.125p ps=5u w=9u l=1u
X544 yp_p zp_m avdd avdd sg13_hv_pmos ad=1.125p pd=5u as=1.125p ps=5u w=9u l=7u
X545 a_21700_1400# bnb bna_ avss sg13_hv_nmos ad=1.125p pd=5u as=1.125p ps=5u w=9u l=1u
X546 yp_p in_m a_27300_200# avss sg13_hv_nmos ad=1.125p pd=5u as=1.125p ps=5u w=9u l=1u
X547 bna_ bnb a_22900_200# avss sg13_hv_nmos ad=1.125p pd=5u as=1.125p ps=5u w=9u l=1u
X548 bpb bpb bpa_r avdd sg13_hv_pmos ad=1.125p pd=5u as=1.125p ps=5u w=9u l=1u
X549 zn_m zn_m a_44900_200# avss sg13_hv_nmos ad=1.125p pd=5u as=1.125p ps=5u w=9u l=1u
X550 bpb bpb bpa_l avdd sg13_hv_pmos ad=1.125p pd=5u as=1.125p ps=5u w=9u l=1u
X551 a_26900_1400# in_m yp_p avss sg13_hv_nmos ad=1.125p pd=5u as=1.125p ps=5u w=9u l=1u
X552 yp_m in_p a_28900_1400# avss sg13_hv_nmos ad=1.125p pd=5u as=1.125p ps=5u w=9u l=1u
X553 zp_m zp_m yp_p avdd sg13_hv_pmos ad=1.125p pd=5u as=1.125p ps=5u w=9u l=1u
X554 zn_m bpb a_46700_5000# avdd sg13_hv_pmos ad=1.125p pd=5u as=1.125p ps=5u w=9u l=1u
X555 yn_m in_p xp avdd sg13_hv_pmos ad=1.125p pd=5u as=1.125p ps=5u w=9u l=1u
X556 avdd zp_p out avdd sg13_hv_pmos ad=1.125p pd=5u as=1.125p ps=5u w=9u l=1u
X557 bpb bpb bpa_r avdd sg13_hv_pmos ad=1.125p pd=5u as=1.125p ps=5u w=9u l=1u
X558 bpb bpb bpa_l avdd sg13_hv_pmos ad=1.125p pd=5u as=1.125p ps=5u w=9u l=1u
X559 zp_m bnb a_39300_1400# avss sg13_hv_nmos ad=1.125p pd=5u as=1.125p ps=5u w=9u l=1u
X560 bna_ bna_ a_16500_1400# avss sg13_hv_nmos ad=1.125p pd=5u as=1.125p ps=5u w=9u l=1u
X561 xp in_m yn_p avdd sg13_hv_pmos ad=1.125p pd=5u as=1.125p ps=5u w=9u l=1u
X562 out zp_p avdd avdd sg13_hv_pmos ad=1.125p pd=5u as=1.125p ps=5u w=9u l=1u
X563 a_16900_200# bnb bna_ avss sg13_hv_nmos ad=1.125p pd=5u as=1.125p ps=5u w=9u l=1u
X564 bnb bnb a_21700_1400# avss sg13_hv_nmos ad=1.125p pd=5u as=1.125p ps=5u w=9u l=1u
X565 xn in_p a_29300_200# avss sg13_hv_nmos ad=1.125p pd=5u as=1.125p ps=5u w=9u l=1u
X566 yn_p zn_m a_46900_200# avss sg13_hv_nmos ad=1.125p pd=5u as=1.125p ps=5u w=9u l=1u
X567 a_24100_1400# bna_ a_23900_1400# avss sg13_hv_nmos ad=1.125p pd=5u as=1.125p ps=5u w=9u l=1u
X568 a_43900_5000# bpb zn_m avdd sg13_hv_pmos ad=1.125p pd=5u as=1.125p ps=5u w=9u l=1u
X569 bpb bpb bpa_l avdd sg13_hv_pmos ad=1.125p pd=5u as=1.125p ps=5u w=9u l=1u
X570 a_20900_6200# bpa_r bpa_r avdd sg13_hv_pmos ad=1.125p pd=5u as=1.125p ps=5u w=9u l=1u
X571 yp_p zp_m avdd avdd sg13_hv_pmos ad=1.125p pd=5u as=1.125p ps=5u w=9u l=7u
X572 yp_p zp_m zp_m avdd sg13_hv_pmos ad=1.125p pd=5u as=1.125p ps=5u w=9u l=1u
X573 a_29300_1400# in_p yp_m avss sg13_hv_nmos ad=1.125p pd=5u as=1.125p ps=5u w=9u l=1u
X574 avss zn_p a_56500_1400# avss sg13_hv_nmos ad=1.125p pd=5u as=1.125p ps=5u w=9u l=1u
X575 a_51300_200# zn_m yn_m avss sg13_hv_nmos ad=1.125p pd=5u as=1.125p ps=5u w=9u l=1u
X576 yp_p in_m a_26500_200# avss sg13_hv_nmos ad=1.125p pd=5u as=1.125p ps=5u w=9u l=1u
X577 a_35100_1400# zn_m avss avss sg13_hv_nmos ad=1.125p pd=5u as=1.125p ps=5u w=9u l=7u
X578 a_39300_200# bnb a_39100_200# avss sg13_hv_nmos ad=1.125p pd=5u as=1.125p ps=5u w=9u l=1u
X579 bpa_r bpb bpb avdd sg13_hv_pmos ad=1.125p pd=5u as=1.125p ps=5u w=9u l=1u
X580 a_12300_5000# bpa_l a_12100_5000# avdd sg13_hv_pmos ad=1.125p pd=5u as=1.125p ps=5u w=9u l=1u
X581 a_16900_1400# bnb bna_ avss sg13_hv_nmos ad=1.125p pd=5u as=1.125p ps=5u w=9u l=1u
X582 bna_ bnb a_18900_1400# avss sg13_hv_nmos ad=1.125p pd=5u as=1.125p ps=5u w=9u l=1u
X583 a_18900_200# bnb bnb avss sg13_hv_nmos ad=1.125p pd=5u as=1.125p ps=5u w=9u l=1u
X584 a_40900_200# bnb a_39100_200# avss sg13_hv_nmos ad=1.125p pd=5u as=1.125p ps=5u w=9u l=1u
X585 a_24300_1400# bna_ a_24100_1400# avss sg13_hv_nmos ad=1.125p pd=5u as=1.125p ps=5u w=9u l=1u
X586 out zp_p avdd avdd sg13_hv_pmos ad=1.125p pd=5u as=1.125p ps=5u w=9u l=1u
X587 a_51700_1400# bnb zn_p avss sg13_hv_nmos ad=1.125p pd=5u as=1.125p ps=5u w=9u l=1u
X588 bpa_r bpb bpb avdd sg13_hv_pmos ad=1.125p pd=5u as=1.125p ps=5u w=9u l=1u
X589 bpa_l bpb bpb avdd sg13_hv_pmos ad=1.125p pd=5u as=1.125p ps=5u w=9u l=1u
X590 a_20500_200# bnb bnb avss sg13_hv_nmos ad=1.125p pd=5u as=1.125p ps=5u w=9u l=1u
X591 a_16100_200# bna_ a_15900_200# avss sg13_hv_nmos ad=1.125p pd=5u as=1.125p ps=5u w=9u l=1u
X592 xn in_p a_29300_1400# avss sg13_hv_nmos ad=1.125p pd=5u as=1.125p ps=5u w=9u l=1u
X593 a_56900_1400# zn_p avss avss sg13_hv_nmos ad=1.125p pd=5u as=1.125p ps=5u w=9u l=1u
X594 xn in_p a_28500_200# avss sg13_hv_nmos ad=1.125p pd=5u as=1.125p ps=5u w=9u l=1u
X595 avdd zp_p out avdd sg13_hv_pmos ad=1.125p pd=5u as=1.125p ps=5u w=9u l=1u
X596 a_53300_200# zn_m zn_p avss sg13_hv_nmos ad=1.125p pd=5u as=1.125p ps=5u w=9u l=1u
X597 avss zn_p a_58900_1400# avss sg13_hv_nmos ad=1.125p pd=5u as=1.125p ps=5u w=9u l=1u
X598 a_45700_1400# zn_m yn_p avss sg13_hv_nmos ad=1.125p pd=5u as=1.125p ps=5u w=9u l=1u
X599 a_19300_1400# bnb bna_ avss sg13_hv_nmos ad=1.125p pd=5u as=1.125p ps=5u w=9u l=1u
X600 zp_p bpb zn_p avdd sg13_hv_pmos ad=1.125p pd=5u as=1.125p ps=5u w=9u l=1u
X601 a_24500_1400# bna_ a_24300_1400# avss sg13_hv_nmos ad=1.125p pd=5u as=1.125p ps=5u w=9u l=1u
X602 zp_p bnb a_51700_1400# avss sg13_hv_nmos ad=1.125p pd=5u as=1.125p ps=5u w=9u l=1u
X603 a_18100_200# bnb bnb avss sg13_hv_nmos ad=1.125p pd=5u as=1.125p ps=5u w=9u l=1u
X604 a_54100_1400# zn_m zn_p avss sg13_hv_nmos ad=1.125p pd=5u as=1.125p ps=5u w=9u l=1u
X605 a_39100_200# bnb a_40500_1400# avss sg13_hv_nmos ad=1.125p pd=5u as=1.125p ps=5u w=9u l=1u
X606 a_16900_5000# bpa_r avdd avdd sg13_hv_pmos ad=1.125p pd=5u as=1.125p ps=5u w=9u l=1u
X607 avdd bpa bnb avdd sg13_hv_pmos ad=1.125p pd=5u as=1.125p ps=5u w=9u l=7u
X608 a_22500_200# bnb bna_ avss sg13_hv_nmos ad=1.125p pd=5u as=1.125p ps=5u w=9u l=1u
X609 avdd bpa bpa avdd sg13_hv_pmos ad=1.125p pd=5u as=1.125p ps=5u w=9u l=7u
X610 a_40100_200# bnb a_39100_200# avss sg13_hv_nmos ad=1.125p pd=5u as=1.125p ps=5u w=9u l=1u
X611 zn_p enb avss avss sg13_hv_nmos ad=1.125p pd=5u as=1.125p ps=5u w=9u l=3u
X612 zn_m zn_m a_45700_1400# avss sg13_hv_nmos ad=1.125p pd=5u as=1.125p ps=5u w=9u l=1u
X613 avss zn_m a_47900_1400# avss sg13_hv_nmos ad=1.125p pd=5u as=1.125p ps=5u w=9u l=7u
X614 avdd zp_p out avdd sg13_hv_pmos ad=1.125p pd=5u as=1.125p ps=5u w=9u l=1u
X615 avdd zp_m yp_m avdd sg13_hv_pmos ad=1.125p pd=5u as=1.125p ps=5u w=9u l=7u
X616 xp bpa avdd avdd sg13_hv_pmos ad=1.125p pd=5u as=1.125p ps=5u w=9u l=7u
X617 bpb bpb bpa_r avdd sg13_hv_pmos ad=1.125p pd=5u as=1.125p ps=5u w=9u l=1u
X618 bnb bpa avdd avdd sg13_hv_pmos ad=1.125p pd=5u as=1.125p ps=5u w=9u l=7u
X619 a_12100_6200# bpa_l avdd avdd sg13_hv_pmos ad=1.125p pd=5u as=1.125p ps=5u w=9u l=1u
X620 a_56900_200# zn_p avss avss sg13_hv_nmos ad=1.125p pd=5u as=1.125p ps=5u w=9u l=1u
X621 bnb bnb a_19300_1400# avss sg13_hv_nmos ad=1.125p pd=5u as=1.125p ps=5u w=9u l=1u
X622 yp_p zp_m zp_m avdd sg13_hv_pmos ad=1.125p pd=5u as=1.125p ps=5u w=9u l=1u
X623 a_46700_5000# bpb zn_m avdd sg13_hv_pmos ad=1.125p pd=5u as=1.125p ps=5u w=9u l=1u
X624 xp in_p yn_m avdd sg13_hv_pmos ad=1.125p pd=5u as=1.125p ps=5u w=9u l=1u
X625 a_44900_200# zn_m yn_p avss sg13_hv_nmos ad=1.125p pd=5u as=1.125p ps=5u w=9u l=1u
X626 out zp_p a_56300_6200# avdd sg13_hv_pmos ad=1.125p pd=5u as=1.125p ps=5u w=9u l=1u
X627 zp_p bpb zn_p avdd sg13_hv_pmos ad=1.125p pd=5u as=1.125p ps=5u w=9u l=1u
X628 bpa_l bpb bpb avdd sg13_hv_pmos ad=1.125p pd=5u as=1.125p ps=5u w=9u l=1u
X629 a_24500_200# bna_ a_24300_200# avss sg13_hv_nmos ad=1.125p pd=5u as=1.125p ps=5u w=9u l=1u
X630 yn_m zn_m a_54100_1400# avss sg13_hv_nmos ad=1.125p pd=5u as=1.125p ps=5u w=9u l=1u
X631 a_40900_1400# bnb a_39100_200# avss sg13_hv_nmos ad=1.125p pd=5u as=1.125p ps=5u w=9u l=1u
X632 a_46500_200# zn_m yn_p avss sg13_hv_nmos ad=1.125p pd=5u as=1.125p ps=5u w=9u l=1u
X633 yp_m zp_m zp_p avdd sg13_hv_pmos ad=1.125p pd=5u as=1.125p ps=5u w=9u l=1u
X634 a_21700_200# bnb bna_ avss sg13_hv_nmos ad=1.125p pd=5u as=1.125p ps=5u w=9u l=1u
X635 avdd en bpa avdd sg13_hv_pmos ad=1.125p pd=5u as=1.125p ps=5u w=9u l=3u
X636 avss bna a_14300_1400# avss sg13_hv_nmos ad=1.125p pd=5u as=1.125p ps=5u w=9u l=7u
X637 avdd zp_m yp_p avdd sg13_hv_pmos ad=1.125p pd=5u as=1.125p ps=5u w=9u l=7u
X638 a_58900_200# zn_p out avss sg13_hv_nmos ad=1.125p pd=5u as=1.125p ps=5u w=9u l=1u
X639 bpa_l bpb bpb avdd sg13_hv_pmos ad=1.125p pd=5u as=1.125p ps=5u w=9u l=1u
X640 avdd bpa_r a_21300_5000# avdd sg13_hv_pmos ad=1.125p pd=5u as=1.125p ps=5u w=9u l=1u
X641 zn_p bpb zp_p avdd sg13_hv_pmos ad=1.125p pd=5u as=1.125p ps=5u w=9u l=1u
X642 a_56100_200# zn_p avss avss sg13_hv_nmos ad=1.125p pd=5u as=1.125p ps=5u w=9u l=1u
X643 tihi tihi avdd avdd sg13_hv_pmos ad=1.125p pd=5u as=1.125p ps=5u w=9u l=19u
X644 a_55100_1400# zn_m yn_m avss sg13_hv_nmos ad=1.125p pd=5u as=1.125p ps=5u w=9u l=7u
X645 out zp_p avdd avdd sg13_hv_pmos ad=1.125p pd=5u as=1.125p ps=5u w=9u l=1u
X646 xp in_m yn_p avdd sg13_hv_pmos ad=1.125p pd=5u as=1.125p ps=5u w=9u l=1u
X647 yn_p zn_m a_43900_200# avss sg13_hv_nmos ad=1.125p pd=5u as=1.125p ps=5u w=9u l=7u
X648 avdd bpa_l a_16500_6200# avdd sg13_hv_pmos ad=1.125p pd=5u as=1.125p ps=5u w=9u l=1u
X649 a_43900_1400# zn_m avss avss sg13_hv_nmos ad=1.125p pd=5u as=1.125p ps=5u w=9u l=7u
X650 a_15500_200# bna_ a_15300_200# avss sg13_hv_nmos ad=1.125p pd=5u as=1.125p ps=5u w=9u l=1u
X651 yn_m in_p xp avdd sg13_hv_pmos ad=1.125p pd=5u as=1.125p ps=5u w=9u l=1u
X652 a_23700_200# bna_ a_23500_200# avss sg13_hv_nmos ad=1.125p pd=5u as=1.125p ps=5u w=9u l=1u
X653 xn bna a_25500_1400# avss sg13_hv_nmos ad=1.125p pd=5u as=1.125p ps=5u w=9u l=7u
X654 a_45700_200# zn_m yn_p avss sg13_hv_nmos ad=1.125p pd=5u as=1.125p ps=5u w=9u l=1u
X655 bpb bpb bpa_l avdd sg13_hv_pmos ad=1.125p pd=5u as=1.125p ps=5u w=9u l=1u
X656 bpb bpb bpa_r avdd sg13_hv_pmos ad=1.125p pd=5u as=1.125p ps=5u w=9u l=1u
X657 yp_p zp_m avdd avdd sg13_hv_pmos ad=1.125p pd=5u as=1.125p ps=5u w=9u l=7u
X658 bpa en avdd avdd sg13_hv_pmos ad=1.125p pd=5u as=1.125p ps=5u w=9u l=3u
X659 zp_m zp_m yp_p avdd sg13_hv_pmos ad=1.125p pd=5u as=1.125p ps=5u w=9u l=1u
X660 zn_m bpb a_46700_5000# avdd sg13_hv_pmos ad=1.125p pd=5u as=1.125p ps=5u w=9u l=1u
X661 yn_m in_p xp avdd sg13_hv_pmos ad=1.125p pd=5u as=1.125p ps=5u w=9u l=1u
X662 yp_m zp_m avdd avdd sg13_hv_pmos ad=1.125p pd=5u as=1.125p ps=5u w=9u l=7u
X663 a_58100_200# zn_p out avss sg13_hv_nmos ad=1.125p pd=5u as=1.125p ps=5u w=9u l=1u
.ends

.subckt lpopamp_core zn_p out inm ib zp_p inp en avdd SUB
XsliceB_1 inm inp out SUB avdd ib en zp_p zn_p lpopamp_sliceB
XsliceA_0 inm inp out SUB avdd ib en zp_p zn_p lpopamp_sliceA
XsliceA_1 inm inp out SUB avdd ib en zp_p zn_p lpopamp_sliceA
XsliceB_0 inm inp out SUB avdd ib en zp_p zn_p lpopamp_sliceB
.ends

.subckt lpopamp en avdd inp SUB inm out ib
Xlpopamp_core_0 zn_p out inm ib zp_p inp en avdd SUB lpopamp_core
.ends

.subckt slot10_wrapper s10_an[0] s10_an[1] s10_an[2] s10_an_0_esd s10_an_1_esd s10_an_2_esd
+ vbias dig_in[23] dig_in[22] dig_in[21] dig_in[20] dig_in[19] dig_in[18] dig_in[17]
+ dig_in[16] dig_in[15] dig_in[14] dig_in[13] dig_in[12] dig_in[11] dig_in[10] dig_in[9]
+ dig_in[8] dig_in[7] dig_in[6] dig_in[5] dig_in[4] dig_in[3] dig_in[2] dig_in[1]
+ dig_in[0] dig_out[11] dig_out[10] dig_out[9] dig_out[8] dig_out[7] dig_out[6] dig_out[5]
+ dig_out[4] dig_out[3] dig_out[2] dig_out[1] dig_out[0] ibias0 ibias1 analog_bus3
+ analog_bus2 analog_bus1 analog_bus0 vss_1v2 vdd_1v2 vss_3v3 vdd_3v3 enable clk reset
Xlvlshifter_0 enable lvlshifter_0/out vdd_1v2 avdd vdd_1v2 lvlshifter
Xlpopamp_0 lpopamp_0/en avdd inp vdd_1v2 inm out ib lpopamp
R0 out s10_an[1] 0.012571
R1 out s10_an[1] 0.012571
R2 ibias0 ib 0.029333
R3 inp s10_an[0] 0.001833
R4 vss_3v3 vdd_1v2 0.000300
R5 out s10_an[1] 0.012571
R6 inm s10_an[2] 0.001833
R7 vdd_3v3 avdd 0.000300
R8 out s10_an[1] 0.012571
.ends
