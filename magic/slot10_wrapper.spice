* NGSPICE file created from slot10_wrapper.ext - technology: ihp-sg13cmos5l

.subckt lpopamp_sliceB in_m in_p out avss avdd ib en zp_p zn_p
X0 a_27700_6600# in_p yp_m avss sg13_hv_nmos ad=1.125p pd=5u as=1.125p ps=5u w=4.5u l=0.5u
X1 a_46700_600# bpb zn_m avdd sg13_hv_pmos ad=1.125p pd=5u as=1.125p ps=5u w=4.5u l=0.5u
X2 bnb bnb a_20900_6600# avss sg13_hv_nmos ad=1.125p pd=5u as=1.125p ps=5u w=4.5u l=0.5u
X3 avdd zp_m yp_p avdd sg13_hv_pmos ad=1.125p pd=5u as=1.125p ps=5u w=4.5u l=3.5u
X4 bpb bpb bpa_r avdd sg13_hv_pmos ad=1.125p pd=5u as=1.125p ps=5u w=4.5u l=0.5u
X5 bna_ bnb a_19700_5400# avss sg13_hv_nmos ad=1.125p pd=5u as=1.125p ps=5u w=4.5u l=0.5u
X6 avdd zp_p out avdd sg13_hv_pmos ad=1.125p pd=5u as=1.125p ps=5u w=4.5u l=0.5u
X7 a_58900_5400# zn_p out avss sg13_hv_nmos ad=1.125p pd=5u as=1.125p ps=5u w=4.5u l=0.5u
X8 avdd zp_m yp_p avdd sg13_hv_pmos ad=1.125p pd=5u as=1.125p ps=5u w=4.5u l=3.5u
X9 zn_p bnb a_52100_5400# avss sg13_hv_nmos ad=1.125p pd=5u as=1.125p ps=5u w=4.5u l=0.5u
X10 bpb bpb bpa_r avdd sg13_hv_pmos ad=1.125p pd=5u as=1.125p ps=5u w=4.5u l=0.5u
X11 yn_p zn_m a_46100_6600# avss sg13_hv_nmos ad=1.125p pd=5u as=1.125p ps=5u w=4.5u l=0.5u
X12 a_23700_5400# bna_ a_23500_5400# avss sg13_hv_nmos ad=1.125p pd=5u as=1.125p ps=5u w=4.5u l=0.5u
X13 a_28100_5400# in_m xn avss sg13_hv_nmos ad=1.125p pd=5u as=1.125p ps=5u w=4.5u l=0.5u
X14 xp in_p yn_m avdd sg13_hv_pmos ad=1.125p pd=5u as=1.125p ps=5u w=4.5u l=0.5u
X15 a_17700_6600# bnb bna_ avss sg13_hv_nmos ad=1.125p pd=5u as=1.125p ps=5u w=4.5u l=0.5u
X16 avss zn_p a_56500_6600# avss sg13_hv_nmos ad=1.125p pd=5u as=1.125p ps=5u w=4.5u l=0.5u
X17 a_39100_5400# bna a_38300_5400# avss sg13_hv_nmos ad=1.125p pd=5u as=1.125p ps=5u w=4.5u l=3.5u
X18 zn_p bpb zp_p avdd sg13_hv_pmos ad=1.125p pd=5u as=1.125p ps=5u w=4.5u l=0.5u
X19 a_21300_600# bpa_r a_21100_600# avdd sg13_hv_pmos ad=1.125p pd=5u as=1.125p ps=5u w=4.5u l=0.5u
X20 a_46700_600# bpb zn_m avdd sg13_hv_pmos ad=1.125p pd=5u as=1.125p ps=5u w=4.5u l=0.5u
X21 bna_ bnb a_21300_6600# avss sg13_hv_nmos ad=1.125p pd=5u as=1.125p ps=5u w=4.5u l=0.5u
X22 a_49500_5400# zn_m avss avss sg13_hv_nmos ad=1.125p pd=5u as=1.125p ps=5u w=4.5u l=3.5u
X23 bpa_l bpb bpb avdd sg13_hv_pmos ad=1.125p pd=5u as=1.125p ps=5u w=4.5u l=0.5u
X24 avdd zp_p out avdd sg13_hv_pmos ad=1.125p pd=5u as=1.125p ps=5u w=4.5u l=0.5u
X25 bpb bpb bpa_r avdd sg13_hv_pmos ad=1.125p pd=5u as=1.125p ps=5u w=4.5u l=0.5u
X26 yp_p zp_m zp_m avdd sg13_hv_pmos ad=1.125p pd=5u as=1.125p ps=5u w=4.5u l=0.5u
X27 a_12300_1800# bpa_l a_12100_1800# avdd sg13_hv_pmos ad=1.125p pd=5u as=1.125p ps=5u w=4.5u l=0.5u
X28 a_14300_5400# bna bpb avss sg13_hv_nmos ad=1.125p pd=5u as=1.125p ps=5u w=4.5u l=3.5u
X29 zp_p zp_m yp_m avdd sg13_hv_pmos ad=1.125p pd=5u as=1.125p ps=5u w=4.5u l=0.5u
X30 zp_p bnb a_52500_5400# avss sg13_hv_nmos ad=1.125p pd=5u as=1.125p ps=5u w=4.5u l=0.5u
X31 a_18100_5400# bnb bnb avss sg13_hv_nmos ad=1.125p pd=5u as=1.125p ps=5u w=4.5u l=0.5u
X32 out zn_p a_56900_5400# avss sg13_hv_nmos ad=1.125p pd=5u as=1.125p ps=5u w=4.5u l=0.5u
X33 enb en avdd avdd sg13_hv_pmos ad=1.125p pd=5u as=2.25p ps=10u w=4.5u l=1.5u
X34 zn_m zn_m a_46500_6600# avss sg13_hv_nmos ad=1.125p pd=5u as=1.125p ps=5u w=4.5u l=0.5u
X35 a_28500_5400# in_m yp_p avss sg13_hv_nmos ad=1.125p pd=5u as=1.125p ps=5u w=4.5u l=0.5u
X36 xp in_p yn_m avdd sg13_hv_pmos ad=1.125p pd=5u as=1.125p ps=5u w=4.5u l=0.5u
X37 yp_p zp_m zp_m avdd sg13_hv_pmos ad=1.125p pd=5u as=1.125p ps=5u w=4.5u l=0.5u
X38 a_40100_6600# bnb a_39100_5400# avss sg13_hv_nmos ad=1.125p pd=5u as=1.125p ps=5u w=4.5u l=0.5u
X39 avdd zp_p out avdd sg13_hv_pmos ad=1.125p pd=5u as=1.125p ps=5u w=4.5u l=0.5u
X40 a_50500_6600# zn_m yn_m avss sg13_hv_nmos ad=1.125p pd=5u as=1.125p ps=5u w=4.5u l=0.5u
X41 a_46700_600# bpb zn_m avdd sg13_hv_pmos ad=1.125p pd=5u as=1.125p ps=5u w=4.5u l=0.5u
X42 bnb bnb a_21700_6600# avss sg13_hv_nmos ad=1.125p pd=5u as=1.125p ps=5u w=4.5u l=0.5u
X43 bpa_r bpa_r a_17300_600# avdd sg13_hv_pmos ad=1.125p pd=5u as=1.125p ps=5u w=4.5u l=0.5u
X44 zp_m zp_m yp_p avdd sg13_hv_pmos ad=1.125p pd=5u as=1.125p ps=5u w=4.5u l=0.5u
X45 avdd zp_m yp_m avdd sg13_hv_pmos ad=1.125p pd=5u as=1.125p ps=5u w=4.5u l=3.5u
X46 bpa_l bpa_l a_12500_1800# avdd sg13_hv_pmos ad=1.125p pd=5u as=1.125p ps=5u w=4.5u l=0.5u
X47 yn_p zn_m a_46900_5400# avss sg13_hv_nmos ad=1.125p pd=5u as=1.125p ps=5u w=4.5u l=0.5u
X48 a_17100_1800# bpa_r a_16900_1800# avdd sg13_hv_pmos ad=1.125p pd=5u as=1.125p ps=5u w=4.5u l=0.5u
X49 a_18500_5400# bnb bna_ avss sg13_hv_nmos ad=1.125p pd=5u as=1.125p ps=5u w=4.5u l=0.5u
X50 zp_p zp_m yp_m avdd sg13_hv_pmos ad=1.125p pd=5u as=1.125p ps=5u w=4.5u l=0.5u
X51 out zp_p avdd avdd sg13_hv_pmos ad=1.125p pd=5u as=1.125p ps=5u w=4.5u l=0.5u
X52 bpa_r bpb bpb avdd sg13_hv_pmos ad=1.125p pd=5u as=1.125p ps=5u w=4.5u l=0.5u
X53 avss zn_p a_57300_5400# avss sg13_hv_nmos ad=1.125p pd=5u as=1.125p ps=5u w=4.5u l=0.5u
X54 avdd en enb avdd sg13_hv_pmos ad=1.125p pd=5u as=1.125p ps=5u w=4.5u l=1.5u
X55 a_28900_5400# in_m xn avss sg13_hv_nmos ad=1.125p pd=5u as=1.125p ps=5u w=4.5u l=0.5u
X56 bpa en avdd avdd sg13_hv_pmos ad=1.125p pd=5u as=1.125p ps=5u w=4.5u l=1.5u
X57 a_40500_6600# bnb zp_m avss sg13_hv_nmos ad=1.125p pd=5u as=1.125p ps=5u w=4.5u l=0.5u
X58 bpa bpa avdd avdd sg13_hv_pmos ad=1.125p pd=5u as=1.125p ps=5u w=4.5u l=3.5u
X59 bna_ bnb a_22100_5400# avss sg13_hv_nmos ad=1.125p pd=5u as=1.125p ps=5u w=4.5u l=0.5u
X60 bpb bpb bpa_l avdd sg13_hv_pmos ad=1.125p pd=5u as=1.125p ps=5u w=4.5u l=0.5u
X61 a_50900_6600# zn_m zn_p avss sg13_hv_nmos ad=1.125p pd=5u as=1.125p ps=5u w=4.5u l=0.5u
X62 xp bpa avdd avdd sg13_hv_pmos ad=1.125p pd=5u as=1.125p ps=5u w=4.5u l=3.5u
X63 a_16300_6600# bna_ a_16100_6600# avss sg13_hv_nmos ad=1.125p pd=5u as=1.125p ps=5u w=4.5u l=0.5u
X64 avss zn_m a_55100_6600# avss sg13_hv_nmos ad=1.125p pd=5u as=1.125p ps=5u w=4.5u l=3.5u
X65 enb en avdd avdd sg13_hv_pmos ad=1.125p pd=5u as=2.25p ps=10u w=4.5u l=1.5u
X66 zp_m zp_m yp_p avdd sg13_hv_pmos ad=1.125p pd=5u as=1.125p ps=5u w=4.5u l=0.5u
X67 yp_m in_p a_26500_6600# avss sg13_hv_nmos ad=1.125p pd=5u as=1.125p ps=5u w=4.5u l=0.5u
X68 avss bna a_7100_6600# avss sg13_hv_nmos ad=1.125p pd=5u as=1.125p ps=5u w=4.5u l=3.5u
X69 yn_m in_p xp avdd sg13_hv_pmos ad=1.125p pd=5u as=1.125p ps=5u w=4.5u l=0.5u
X70 a_46700_600# bpa avdd avdd sg13_hv_pmos ad=1.125p pd=5u as=1.125p ps=5u w=4.5u l=3.5u
X71 a_20100_6600# bnb bna_ avss sg13_hv_nmos ad=1.125p pd=5u as=1.125p ps=5u w=4.5u l=0.5u
X72 a_18900_5400# bnb bnb avss sg13_hv_nmos ad=1.125p pd=5u as=1.125p ps=5u w=4.5u l=0.5u
X73 out zp_p avdd avdd sg13_hv_pmos ad=1.125p pd=5u as=1.125p ps=5u w=4.5u l=0.5u
X74 bpa_r bpa_r a_17300_1800# avdd sg13_hv_pmos ad=1.125p pd=5u as=1.125p ps=5u w=4.5u l=0.5u
X75 avss bna a_30300_6600# avss sg13_hv_nmos ad=1.125p pd=5u as=1.125p ps=5u w=4.5u l=3.5u
X76 out zp_p avdd avdd sg13_hv_pmos ad=1.125p pd=5u as=1.125p ps=5u w=4.5u l=0.5u
X77 out zn_p a_57700_5400# avss sg13_hv_nmos ad=1.125p pd=5u as=1.125p ps=5u w=4.5u l=0.5u
X78 a_51300_5400# zn_m yn_m avss sg13_hv_nmos ad=1.125p pd=5u as=1.125p ps=5u w=4.5u l=0.5u
X79 a_40900_6600# bnb a_39100_5400# avss sg13_hv_nmos ad=1.125p pd=5u as=1.125p ps=5u w=4.5u l=0.5u
X80 yp_m zp_m zp_p avdd sg13_hv_pmos ad=1.125p pd=5u as=1.125p ps=5u w=4.5u l=0.5u
X81 avdd en bpa avdd sg13_hv_pmos ad=1.125p pd=5u as=1.125p ps=5u w=4.5u l=1.5u
X82 bnb bnb a_22500_5400# avss sg13_hv_nmos ad=1.125p pd=5u as=1.125p ps=5u w=4.5u l=0.5u
X83 a_16900_600# bpa_r avdd avdd sg13_hv_pmos ad=1.125p pd=5u as=1.125p ps=5u w=4.5u l=0.5u
X84 a_21300_1800# bpa_r a_21100_1800# avdd sg13_hv_pmos ad=1.125p pd=5u as=1.125p ps=5u w=4.5u l=0.5u
X85 a_45300_6600# zn_m zn_m avss sg13_hv_nmos ad=1.125p pd=5u as=1.125p ps=5u w=4.5u l=0.5u
X86 enb en avss avss sg13_hv_nmos ad=1.125p pd=5u as=2.25p ps=10u w=4.5u l=1.5u
X87 xn in_p a_26900_5400# avss sg13_hv_nmos ad=1.125p pd=5u as=1.125p ps=5u w=4.5u l=0.5u
X88 bna_ bna_ a_16500_6600# avss sg13_hv_nmos ad=1.125p pd=5u as=1.125p ps=5u w=4.5u l=0.5u
X89 a_43900_600# bpb zn_m avdd sg13_hv_pmos ad=1.125p pd=5u as=1.125p ps=5u w=4.5u l=0.5u
X90 yn_p in_m xp avdd sg13_hv_pmos ad=1.125p pd=5u as=1.125p ps=5u w=4.5u l=0.5u
X91 avdd bpa bpa avdd sg13_hv_pmos ad=1.125p pd=5u as=1.125p ps=5u w=4.5u l=3.5u
X92 a_20500_6600# bnb bnb avss sg13_hv_nmos ad=1.125p pd=5u as=1.125p ps=5u w=4.5u l=0.5u
X93 yn_p in_m xp avdd sg13_hv_pmos ad=1.125p pd=5u as=1.125p ps=5u w=4.5u l=0.5u
X94 a_41300_5400# bnb zp_m avss sg13_hv_nmos ad=1.125p pd=5u as=1.125p ps=5u w=4.5u l=0.5u
X95 bpa_r bpb bpb avdd sg13_hv_pmos ad=1.125p pd=5u as=1.125p ps=5u w=4.5u l=0.5u
X96 out zp_p avdd avdd sg13_hv_pmos ad=1.125p pd=5u as=1.125p ps=5u w=4.5u l=0.5u
X97 avdd bpa bpa avdd sg13_hv_pmos ad=1.125p pd=5u as=1.125p ps=5u w=4.5u l=3.5u
X98 yn_p zn_m a_35100_6600# avss sg13_hv_nmos ad=1.125p pd=5u as=1.125p ps=5u w=4.5u l=3.5u
X99 zn_p bpb zp_p avdd sg13_hv_pmos ad=1.125p pd=5u as=1.125p ps=5u w=4.5u l=0.5u
X100 a_51700_5400# bnb zn_p avss sg13_hv_nmos ad=1.125p pd=5u as=1.125p ps=5u w=4.5u l=0.5u
X101 bnb bnb a_16900_5400# avss sg13_hv_nmos ad=1.125p pd=5u as=1.125p ps=5u w=4.5u l=0.5u
X102 bpa bpa avdd avdd sg13_hv_pmos ad=1.125p pd=5u as=1.125p ps=5u w=4.5u l=3.5u
X103 bnb bpa avdd avdd sg13_hv_pmos ad=1.125p pd=5u as=1.125p ps=5u w=4.5u l=3.5u
X104 a_56100_5400# zn_p avss avss sg13_hv_nmos ad=1.125p pd=5u as=1.125p ps=5u w=4.5u l=0.5u
X105 a_45700_6600# zn_m yn_p avss sg13_hv_nmos ad=1.125p pd=5u as=1.125p ps=5u w=4.5u l=0.5u
X106 out zp_p avdd avdd sg13_hv_pmos ad=1.125p pd=5u as=1.125p ps=5u w=4.5u l=0.5u
X107 avss en enb avss sg13_hv_nmos ad=1.125p pd=5u as=1.125p ps=5u w=4.5u l=1.5u
X108 yp_m in_p a_27300_5400# avss sg13_hv_nmos ad=1.125p pd=5u as=1.125p ps=5u w=4.5u l=0.5u
X109 bna enb avss avss sg13_hv_nmos ad=1.125p pd=5u as=1.125p ps=5u w=4.5u l=1.5u
X110 yn_p in_m xp avdd sg13_hv_pmos ad=1.125p pd=5u as=1.125p ps=5u w=4.5u l=0.5u
X111 a_11100_6600# bna bpa avss sg13_hv_nmos ad=1.125p pd=5u as=1.125p ps=5u w=4.5u l=3.5u
X112 bpb bpb bpa_l avdd sg13_hv_pmos ad=1.125p pd=5u as=1.125p ps=5u w=4.5u l=0.5u
X113 a_31900_5400# zn_m avss avss sg13_hv_nmos ad=1.125p pd=5u as=1.125p ps=5u w=4.5u l=3.5u
X114 zn_m bpb a_46700_600# avdd sg13_hv_pmos ad=1.125p pd=5u as=1.125p ps=5u w=4.5u l=0.5u
X115 a_20900_6600# bnb bna_ avss sg13_hv_nmos ad=1.125p pd=5u as=1.125p ps=5u w=4.5u l=0.5u
X116 a_42300_5400# bna a_39100_5400# avss sg13_hv_nmos ad=1.125p pd=5u as=1.125p ps=5u w=4.5u l=3.5u
X117 yp_m zp_m zp_p avdd sg13_hv_pmos ad=1.125p pd=5u as=1.125p ps=5u w=4.5u l=0.5u
X118 a_46100_5400# zn_m zn_m avss sg13_hv_nmos ad=1.125p pd=5u as=1.125p ps=5u w=4.5u l=0.5u
X119 zn_p bpb zp_p avdd sg13_hv_pmos ad=1.125p pd=5u as=1.125p ps=5u w=4.5u l=0.5u
X120 a_16100_1800# bpa_l bpa_l avdd sg13_hv_pmos ad=1.125p pd=5u as=1.125p ps=5u w=4.5u l=0.5u
X121 bna_ bnb a_17300_5400# avss sg13_hv_nmos ad=1.125p pd=5u as=1.125p ps=5u w=4.5u l=0.5u
X122 yp_m zp_m zp_p avdd sg13_hv_pmos ad=1.125p pd=5u as=1.125p ps=5u w=4.5u l=0.5u
X123 a_56500_5400# zn_p out avss sg13_hv_nmos ad=1.125p pd=5u as=1.125p ps=5u w=4.5u l=0.5u
X124 xn in_p a_27700_5400# avss sg13_hv_nmos ad=1.125p pd=5u as=1.125p ps=5u w=4.5u l=0.5u
X125 yp_m zp_m avdd avdd sg13_hv_pmos ad=1.125p pd=5u as=1.125p ps=5u w=4.5u l=3.5u
X126 avss enb bna avss sg13_hv_nmos ad=1.125p pd=5u as=1.125p ps=5u w=4.5u l=1.5u
X127 xp in_m yn_p avdd sg13_hv_pmos ad=1.125p pd=5u as=1.125p ps=5u w=4.5u l=0.5u
X128 a_21300_5400# bnb bnb avss sg13_hv_nmos ad=1.125p pd=5u as=1.125p ps=5u w=4.5u l=0.5u
X129 avdd bpa xp avdd sg13_hv_pmos ad=1.125p pd=5u as=1.125p ps=5u w=4.5u l=3.5u
X130 bpb bpb bpa_r avdd sg13_hv_pmos ad=1.125p pd=5u as=1.125p ps=5u w=4.5u l=0.5u
X131 a_15300_6600# bna_ avss avss sg13_hv_nmos ad=1.125p pd=5u as=1.125p ps=5u w=4.5u l=0.5u
X132 yn_m zn_m a_54100_6600# avss sg13_hv_nmos ad=1.125p pd=5u as=1.125p ps=5u w=4.5u l=0.5u
X133 a_36700_5400# zn_m yn_p avss sg13_hv_nmos ad=1.125p pd=5u as=1.125p ps=5u w=4.5u l=3.5u
X134 xn bna a_25500_6600# avss sg13_hv_nmos ad=1.125p pd=5u as=1.125p ps=5u w=4.5u l=3.5u
X135 a_43900_600# bpb zn_m avdd sg13_hv_pmos ad=1.125p pd=5u as=1.125p ps=5u w=4.5u l=0.5u
X136 avdd bpa bnb avdd sg13_hv_pmos ad=1.125p pd=5u as=1.125p ps=5u w=4.5u l=3.5u
X137 a_46500_5400# zn_m yn_p avss sg13_hv_nmos ad=1.125p pd=5u as=1.125p ps=5u w=4.5u l=0.5u
X138 a_16500_1800# bpa_l a_16300_1800# avdd sg13_hv_pmos ad=1.125p pd=5u as=1.125p ps=5u w=4.5u l=0.5u
X139 bnb bnb a_17700_5400# avss sg13_hv_nmos ad=1.125p pd=5u as=1.125p ps=5u w=4.5u l=0.5u
X140 zn_m bpb a_46700_600# avdd sg13_hv_pmos ad=1.125p pd=5u as=1.125p ps=5u w=4.5u l=0.5u
X141 bpa_l bpb bpb avdd sg13_hv_pmos ad=1.125p pd=5u as=1.125p ps=5u w=4.5u l=0.5u
X142 a_56900_5400# zn_p avss avss sg13_hv_nmos ad=1.125p pd=5u as=1.125p ps=5u w=4.5u l=0.5u
X143 avss bna a_11100_5400# avss sg13_hv_nmos ad=1.125p pd=5u as=1.125p ps=5u w=4.5u l=3.5u
X144 a_9500_5400# bna avss avss sg13_hv_nmos ad=1.125p pd=5u as=1.125p ps=5u w=4.5u l=3.5u
X145 bpa_r bpb bpb avdd sg13_hv_pmos ad=1.125p pd=5u as=1.125p ps=5u w=4.5u l=0.5u
X146 a_21700_5400# bnb bna_ avss sg13_hv_nmos ad=1.125p pd=5u as=1.125p ps=5u w=4.5u l=0.5u
X147 zp_m zp_m yp_p avdd sg13_hv_pmos ad=1.125p pd=5u as=1.125p ps=5u w=4.5u l=0.5u
X148 zp_p bpb zn_p avdd sg13_hv_pmos ad=1.125p pd=5u as=1.125p ps=5u w=4.5u l=0.5u
X149 a_15700_6600# bna_ a_15500_6600# avss sg13_hv_nmos ad=1.125p pd=5u as=1.125p ps=5u w=4.5u l=0.5u
X150 avss zn_p a_58900_6600# avss sg13_hv_nmos ad=1.125p pd=5u as=1.125p ps=5u w=4.5u l=0.5u
X151 yp_m zp_m avdd avdd sg13_hv_pmos ad=1.125p pd=5u as=1.125p ps=5u w=4.5u l=3.5u
X152 a_46900_5400# zn_m zn_m avss sg13_hv_nmos ad=1.125p pd=5u as=1.125p ps=5u w=4.5u l=0.5u
X153 zp_m bnb a_40100_5400# avss sg13_hv_nmos ad=1.125p pd=5u as=1.125p ps=5u w=4.5u l=0.5u
X154 a_16900_1800# bpa_r avdd avdd sg13_hv_pmos ad=1.125p pd=5u as=1.125p ps=5u w=4.5u l=0.5u
X155 bpa_r bpb bpb avdd sg13_hv_pmos ad=1.125p pd=5u as=1.125p ps=5u w=4.5u l=0.5u
X156 zn_p zn_m a_50500_5400# avss sg13_hv_nmos ad=1.125p pd=5u as=1.125p ps=5u w=4.5u l=0.5u
X157 a_16100_5400# bna_ a_15900_5400# avss sg13_hv_nmos ad=1.125p pd=5u as=1.125p ps=5u w=4.5u l=0.5u
X158 bpa_r bpb bpb avdd sg13_hv_pmos ad=1.125p pd=5u as=1.125p ps=5u w=4.5u l=0.5u
X159 a_46700_600# bpa avdd avdd sg13_hv_pmos ad=1.125p pd=5u as=1.125p ps=5u w=4.5u l=3.5u
X160 zp_p zp_m yp_m avdd sg13_hv_pmos ad=1.125p pd=5u as=1.125p ps=5u w=4.5u l=0.5u
X161 a_26500_5400# in_p xn avss sg13_hv_nmos ad=1.125p pd=5u as=1.125p ps=5u w=4.5u l=0.5u
X162 bpa_l bpb bpb avdd sg13_hv_pmos ad=1.125p pd=5u as=1.125p ps=5u w=4.5u l=0.5u
X163 xp in_m yn_p avdd sg13_hv_pmos ad=1.125p pd=5u as=1.125p ps=5u w=4.5u l=0.5u
X164 avss zn_m a_36700_5400# avss sg13_hv_nmos ad=1.125p pd=5u as=1.125p ps=5u w=4.5u l=3.5u
X165 a_24300_6600# bna_ a_24100_6600# avss sg13_hv_nmos ad=1.125p pd=5u as=1.125p ps=5u w=4.5u l=0.5u
X166 a_39100_5400# bnb a_40500_5400# avss sg13_hv_nmos ad=1.125p pd=5u as=1.125p ps=5u w=4.5u l=0.5u
X167 yp_p zp_m zp_m avdd sg13_hv_pmos ad=1.125p pd=5u as=1.125p ps=5u w=4.5u l=0.5u
X168 zn_m zn_m a_44900_5400# avss sg13_hv_nmos ad=1.125p pd=5u as=1.125p ps=5u w=4.5u l=0.5u
X169 a_16500_5400# bna_ a_16300_5400# avss sg13_hv_nmos ad=1.125p pd=5u as=1.125p ps=5u w=4.5u l=0.5u
X170 avdd bpa xp avdd sg13_hv_pmos ad=1.125p pd=5u as=1.125p ps=5u w=4.5u l=3.5u
X171 zp_p bpb zn_p avdd sg13_hv_pmos ad=1.125p pd=5u as=1.125p ps=5u w=4.5u l=0.5u
X172 bpa_l bpb bpb avdd sg13_hv_pmos ad=1.125p pd=5u as=1.125p ps=5u w=4.5u l=0.5u
X173 a_26900_5400# in_p yp_m avss sg13_hv_nmos ad=1.125p pd=5u as=1.125p ps=5u w=4.5u l=0.5u
X174 out zp_p a_58700_600# avdd sg13_hv_pmos ad=1.125p pd=5u as=1.125p ps=5u w=4.5u l=0.5u
X175 a_17100_600# bpa_r a_16900_600# avdd sg13_hv_pmos ad=1.125p pd=5u as=1.125p ps=5u w=4.5u l=0.5u
X176 avdd tihi tihi avdd sg13_hv_pmos ad=1.125p pd=5u as=1.125p ps=5u w=4.5u l=9.5u
X177 bnb bnb a_20100_5400# avss sg13_hv_nmos ad=1.125p pd=5u as=1.125p ps=5u w=4.5u l=0.5u
X178 xp in_m yn_p avdd sg13_hv_pmos ad=1.125p pd=5u as=1.125p ps=5u w=4.5u l=0.5u
X179 zp_p zp_m yp_m avdd sg13_hv_pmos ad=1.125p pd=5u as=1.125p ps=5u w=4.5u l=0.5u
X180 a_53300_6600# zn_m zn_p avss sg13_hv_nmos ad=1.125p pd=5u as=1.125p ps=5u w=4.5u l=0.5u
X181 bpa_r bpb bpb avdd sg13_hv_pmos ad=1.125p pd=5u as=1.125p ps=5u w=4.5u l=0.5u
X182 avss bna_ a_24500_6600# avss sg13_hv_nmos ad=1.125p pd=5u as=1.125p ps=5u w=4.5u l=0.5u
X183 yp_p in_m a_28900_6600# avss sg13_hv_nmos ad=1.125p pd=5u as=1.125p ps=5u w=4.5u l=0.5u
X184 a_12500_600# bpa_l a_12300_600# avdd sg13_hv_pmos ad=1.125p pd=5u as=1.125p ps=5u w=4.5u l=0.5u
X185 avdd en bpa avdd sg13_hv_pmos ad=1.125p pd=5u as=1.125p ps=5u w=4.5u l=1.5u
X186 zn_m bpb a_43900_600# avdd sg13_hv_pmos ad=1.125p pd=5u as=1.125p ps=5u w=4.5u l=0.5u
X187 yn_p zn_m a_45300_5400# avss sg13_hv_nmos ad=1.125p pd=5u as=1.125p ps=5u w=4.5u l=0.5u
X188 a_16900_5400# bnb bna_ avss sg13_hv_nmos ad=1.125p pd=5u as=1.125p ps=5u w=4.5u l=0.5u
X189 bpa_l bpb bpb avdd sg13_hv_pmos ad=1.125p pd=5u as=1.125p ps=5u w=4.5u l=0.5u
X190 zp_m bnb a_39300_6600# avss sg13_hv_nmos ad=1.125p pd=5u as=1.125p ps=5u w=4.5u l=0.5u
X191 yp_p zp_m avdd avdd sg13_hv_pmos ad=1.125p pd=5u as=1.125p ps=5u w=4.5u l=3.5u
X192 zp_p bpb zn_p avdd sg13_hv_pmos ad=1.125p pd=5u as=1.125p ps=5u w=4.5u l=0.5u
X193 bna_ bnb a_20500_5400# avss sg13_hv_nmos ad=1.125p pd=5u as=1.125p ps=5u w=4.5u l=0.5u
X194 a_43900_6600# zn_m avss avss sg13_hv_nmos ad=1.125p pd=5u as=1.125p ps=5u w=4.5u l=3.5u
X195 yn_m in_p xp avdd sg13_hv_pmos ad=1.125p pd=5u as=1.125p ps=5u w=4.5u l=0.5u
X196 out zp_p a_57100_600# avdd sg13_hv_pmos ad=1.125p pd=5u as=1.125p ps=5u w=4.5u l=0.5u
X197 a_53700_6600# zn_m yn_m avss sg13_hv_nmos ad=1.125p pd=5u as=1.125p ps=5u w=4.5u l=0.5u
X198 bna_ bnb a_18900_6600# avss sg13_hv_nmos ad=1.125p pd=5u as=1.125p ps=5u w=4.5u l=0.5u
X199 a_58100_6600# zn_p out avss sg13_hv_nmos ad=1.125p pd=5u as=1.125p ps=5u w=4.5u l=0.5u
X200 ib en bna avss sg13_hv_nmos ad=1.125p pd=5u as=1.125p ps=5u w=4.5u l=1.5u
X201 zn_m bpb a_43900_600# avdd sg13_hv_pmos ad=1.125p pd=5u as=1.125p ps=5u w=4.5u l=0.5u
X202 xn in_m a_29300_6600# avss sg13_hv_nmos ad=1.125p pd=5u as=1.125p ps=5u w=4.5u l=0.5u
X203 a_16500_600# bpa_l a_16300_600# avdd sg13_hv_pmos ad=1.125p pd=5u as=1.125p ps=5u w=4.5u l=0.5u
X204 zn_m zn_m a_45700_5400# avss sg13_hv_nmos ad=1.125p pd=5u as=1.125p ps=5u w=4.5u l=0.5u
X205 bpa_l bpb bpb avdd sg13_hv_pmos ad=1.125p pd=5u as=1.125p ps=5u w=4.5u l=0.5u
X206 zp_p zp_m yp_m avdd sg13_hv_pmos ad=1.125p pd=5u as=1.125p ps=5u w=4.5u l=0.5u
X207 a_39100_5400# bnb a_39700_6600# avss sg13_hv_nmos ad=1.125p pd=5u as=1.125p ps=5u w=4.5u l=0.5u
X208 zp_p en avdd avdd sg13_hv_pmos ad=1.125p pd=5u as=1.125p ps=5u w=4.5u l=1.5u
X209 a_54100_5400# zn_m zn_p avss sg13_hv_nmos ad=1.125p pd=5u as=1.125p ps=5u w=4.5u l=0.5u
X210 yn_p in_m xp avdd sg13_hv_pmos ad=1.125p pd=5u as=1.125p ps=5u w=4.5u l=0.5u
X211 zn_m bpb a_43900_600# avdd sg13_hv_pmos ad=1.125p pd=5u as=1.125p ps=5u w=4.5u l=0.5u
X212 avdd bpa bnb avdd sg13_hv_pmos ad=1.125p pd=5u as=1.125p ps=5u w=4.5u l=3.5u
X213 avss zn_m a_47900_6600# avss sg13_hv_nmos ad=1.125p pd=5u as=1.125p ps=5u w=4.5u l=3.5u
X214 bna en ib avss sg13_hv_nmos ad=1.125p pd=5u as=1.125p ps=5u w=4.5u l=1.5u
X215 xp bpa avdd avdd sg13_hv_pmos ad=1.125p pd=5u as=1.125p ps=5u w=4.5u l=3.5u
X216 bnb bnb a_19300_6600# avss sg13_hv_nmos ad=1.125p pd=5u as=1.125p ps=5u w=4.5u l=0.5u
X217 a_58500_6600# zn_p avss avss sg13_hv_nmos ad=1.125p pd=5u as=1.125p ps=5u w=4.5u l=0.5u
X218 zn_m bpb a_43900_600# avdd sg13_hv_pmos ad=1.125p pd=5u as=1.125p ps=5u w=4.5u l=0.5u
X219 a_23300_6600# bna_ bna_ avss sg13_hv_nmos ad=1.125p pd=5u as=1.125p ps=5u w=4.5u l=0.5u
X220 yn_p zn_m a_43900_5400# avss sg13_hv_nmos ad=1.125p pd=5u as=1.125p ps=5u w=4.5u l=3.5u
X221 avdd en zp_p avdd sg13_hv_pmos ad=2.25p pd=10u as=1.125p ps=5u w=4.5u l=1.5u
X222 avss zn_m a_33500_6600# avss sg13_hv_nmos ad=1.125p pd=5u as=1.125p ps=5u w=4.5u l=3.5u
X223 avdd zp_p out avdd sg13_hv_pmos ad=1.125p pd=5u as=1.125p ps=5u w=4.5u l=0.5u
X224 bpb bpb bpa_l avdd sg13_hv_pmos ad=1.125p pd=5u as=1.125p ps=5u w=4.5u l=0.5u
X225 a_15500_5400# bna_ a_15300_5400# avss sg13_hv_nmos ad=1.125p pd=5u as=1.125p ps=5u w=4.5u l=0.5u
X226 a_55100_5400# zn_m yn_m avss sg13_hv_nmos ad=1.125p pd=5u as=1.125p ps=5u w=4.5u l=3.5u
X227 yp_m zp_m avdd avdd sg13_hv_pmos ad=1.125p pd=5u as=1.125p ps=5u w=4.5u l=3.5u
X228 bpa_l bpb bpb avdd sg13_hv_pmos ad=1.125p pd=5u as=1.125p ps=5u w=4.5u l=0.5u
X229 a_7100_5400# bna bna avss sg13_hv_nmos ad=1.125p pd=5u as=1.125p ps=5u w=4.5u l=3.5u
X230 yp_m zp_m zp_p avdd sg13_hv_pmos ad=1.125p pd=5u as=1.125p ps=5u w=4.5u l=0.5u
X231 bna_ bnb a_19700_6600# avss sg13_hv_nmos ad=1.125p pd=5u as=1.125p ps=5u w=4.5u l=0.5u
X232 a_58900_6600# zn_p out avss sg13_hv_nmos ad=1.125p pd=5u as=1.125p ps=5u w=4.5u l=0.5u
X233 zp_m zp_m yp_p avdd sg13_hv_pmos ad=1.125p pd=5u as=1.125p ps=5u w=4.5u l=0.5u
X234 zn_p bnb a_52100_6600# avss sg13_hv_nmos ad=1.125p pd=5u as=1.125p ps=5u w=4.5u l=0.5u
X235 a_43900_600# bpa avdd avdd sg13_hv_pmos ad=1.125p pd=5u as=1.125p ps=5u w=4.5u l=3.5u
X236 zp_p zp_m yp_m avdd sg13_hv_pmos ad=1.125p pd=5u as=1.125p ps=5u w=4.5u l=0.5u
X237 a_23700_6600# bna_ a_23500_6600# avss sg13_hv_nmos ad=1.125p pd=5u as=1.125p ps=5u w=4.5u l=0.5u
X238 xp in_m yn_p avdd sg13_hv_pmos ad=1.125p pd=5u as=1.125p ps=5u w=4.5u l=0.5u
X239 a_28100_6600# in_m xn avss sg13_hv_nmos ad=1.125p pd=5u as=1.125p ps=5u w=4.5u l=0.5u
X240 bpb bpb bpa_l avdd sg13_hv_pmos ad=1.125p pd=5u as=1.125p ps=5u w=4.5u l=0.5u
X241 a_15900_5400# bna_ a_15700_5400# avss sg13_hv_nmos ad=1.125p pd=5u as=1.125p ps=5u w=4.5u l=0.5u
X242 yp_m zp_m zp_p avdd sg13_hv_pmos ad=1.125p pd=5u as=1.125p ps=5u w=4.5u l=0.5u
X243 a_39100_5400# bna a_38300_6600# avss sg13_hv_nmos ad=1.125p pd=5u as=1.125p ps=5u w=4.5u l=3.5u
X244 yp_m bpa avdd avdd sg13_hv_pmos ad=1.125p pd=5u as=1.125p ps=5u w=4.5u l=3.5u
X245 zn_p enb avss avss sg13_hv_nmos ad=1.125p pd=5u as=1.125p ps=5u w=4.5u l=1.5u
X246 a_49500_6600# zn_m avss avss sg13_hv_nmos ad=1.125p pd=5u as=1.125p ps=5u w=4.5u l=3.5u
X247 bpa_r bpb bpb avdd sg13_hv_pmos ad=1.125p pd=5u as=1.125p ps=5u w=4.5u l=0.5u
X248 yp_m zp_m zp_p avdd sg13_hv_pmos ad=1.125p pd=5u as=1.125p ps=5u w=4.5u l=0.5u
X249 a_24100_5400# bna_ a_23900_5400# avss sg13_hv_nmos ad=1.125p pd=5u as=1.125p ps=5u w=4.5u l=0.5u
X250 avdd zp_m yp_p avdd sg13_hv_pmos ad=1.125p pd=5u as=1.125p ps=5u w=4.5u l=3.5u
X251 a_14300_6600# bna bpb avss sg13_hv_nmos ad=1.125p pd=5u as=1.125p ps=5u w=4.5u l=3.5u
X252 zp_p bnb a_52500_6600# avss sg13_hv_nmos ad=1.125p pd=5u as=1.125p ps=5u w=4.5u l=0.5u
X253 zn_m bpb a_46700_600# avdd sg13_hv_pmos ad=1.125p pd=5u as=1.125p ps=5u w=4.5u l=0.5u
X254 a_18100_6600# bnb bnb avss sg13_hv_nmos ad=1.125p pd=5u as=1.125p ps=5u w=4.5u l=0.5u
X255 a_35100_5400# zn_m avss avss sg13_hv_nmos ad=1.125p pd=5u as=1.125p ps=5u w=4.5u l=3.5u
X256 bpa_l bpb bpb avdd sg13_hv_pmos ad=1.125p pd=5u as=1.125p ps=5u w=4.5u l=0.5u
X257 xp in_p yn_m avdd sg13_hv_pmos ad=1.125p pd=5u as=1.125p ps=5u w=4.5u l=0.5u
X258 out zn_p a_56900_6600# avss sg13_hv_nmos ad=1.125p pd=5u as=1.125p ps=5u w=4.5u l=0.5u
X259 yp_p zp_m zp_m avdd sg13_hv_pmos ad=1.125p pd=5u as=1.125p ps=5u w=4.5u l=0.5u
X260 a_28500_6600# in_m yp_p avss sg13_hv_nmos ad=1.125p pd=5u as=1.125p ps=5u w=4.5u l=0.5u
X261 a_44900_5400# zn_m yn_p avss sg13_hv_nmos ad=1.125p pd=5u as=1.125p ps=5u w=4.5u l=0.5u
X262 zp_p bpb zn_p avdd sg13_hv_pmos ad=1.125p pd=5u as=1.125p ps=5u w=4.5u l=0.5u
X263 zn_p bpb zp_p avdd sg13_hv_pmos ad=1.125p pd=5u as=1.125p ps=5u w=4.5u l=0.5u
X264 bpb bpb bpa_l avdd sg13_hv_pmos ad=1.125p pd=5u as=1.125p ps=5u w=4.5u l=0.5u
X265 bpb bpb bpa_r avdd sg13_hv_pmos ad=1.125p pd=5u as=1.125p ps=5u w=4.5u l=0.5u
X266 avdd zp_p out avdd sg13_hv_pmos ad=1.125p pd=5u as=1.125p ps=5u w=4.5u l=0.5u
X267 avss enb zn_p avss sg13_hv_nmos ad=2.25p pd=10u as=1.125p ps=5u w=4.5u l=1.5u
X268 yp_p zp_m avdd avdd sg13_hv_pmos ad=1.125p pd=5u as=1.125p ps=5u w=4.5u l=3.5u
X269 avdd zp_p out avdd sg13_hv_pmos ad=1.125p pd=5u as=1.125p ps=5u w=4.5u l=0.5u
X270 zn_p bnb a_52900_5400# avss sg13_hv_nmos ad=1.125p pd=5u as=1.125p ps=5u w=4.5u l=0.5u
X271 a_24500_5400# bna_ a_24300_5400# avss sg13_hv_nmos ad=1.125p pd=5u as=1.125p ps=5u w=4.5u l=0.5u
X272 yn_p zn_m a_46900_6600# avss sg13_hv_nmos ad=1.125p pd=5u as=1.125p ps=5u w=4.5u l=0.5u
X273 bpa_r bpb bpb avdd sg13_hv_pmos ad=1.125p pd=5u as=1.125p ps=5u w=4.5u l=0.5u
X274 xp in_p yn_m avdd sg13_hv_pmos ad=1.125p pd=5u as=1.125p ps=5u w=4.5u l=0.5u
X275 a_18500_6600# bnb bna_ avss sg13_hv_nmos ad=1.125p pd=5u as=1.125p ps=5u w=4.5u l=0.5u
X276 avss zn_p a_57300_6600# avss sg13_hv_nmos ad=1.125p pd=5u as=1.125p ps=5u w=4.5u l=0.5u
X277 a_39300_5400# bnb a_39100_5400# avss sg13_hv_nmos ad=1.125p pd=5u as=1.125p ps=5u w=4.5u l=0.5u
X278 a_28900_6600# in_m xn avss sg13_hv_nmos ad=1.125p pd=5u as=1.125p ps=5u w=4.5u l=0.5u
X279 zp_p bpb zn_p avdd sg13_hv_pmos ad=1.125p pd=5u as=1.125p ps=5u w=4.5u l=0.5u
X280 yn_m zn_m a_49500_5400# avss sg13_hv_nmos ad=1.125p pd=5u as=1.125p ps=5u w=4.5u l=3.5u
X281 bna_ bnb a_22100_6600# avss sg13_hv_nmos ad=1.125p pd=5u as=1.125p ps=5u w=4.5u l=0.5u
X282 avdd bpa_r a_21300_600# avdd sg13_hv_pmos ad=1.125p pd=5u as=1.125p ps=5u w=4.5u l=0.5u
X283 avdd zp_p out avdd sg13_hv_pmos ad=1.125p pd=5u as=1.125p ps=5u w=4.5u l=0.5u
X284 bpb bpb bpa_r avdd sg13_hv_pmos ad=1.125p pd=5u as=1.125p ps=5u w=4.5u l=0.5u
X285 avss bna a_14300_5400# avss sg13_hv_nmos ad=1.125p pd=5u as=1.125p ps=5u w=4.5u l=3.5u
X286 avdd bpa bpa avdd sg13_hv_pmos ad=1.125p pd=5u as=1.125p ps=5u w=4.5u l=3.5u
X287 bpa_l bpb bpb avdd sg13_hv_pmos ad=1.125p pd=5u as=1.125p ps=5u w=4.5u l=0.5u
X288 bpb bpb bpa_l avdd sg13_hv_pmos ad=1.125p pd=5u as=1.125p ps=5u w=4.5u l=0.5u
X289 yn_m zn_m a_53300_5400# avss sg13_hv_nmos ad=1.125p pd=5u as=1.125p ps=5u w=4.5u l=0.5u
X290 a_25500_5400# bna avss avss sg13_hv_nmos ad=1.125p pd=5u as=1.125p ps=5u w=4.5u l=3.5u
X291 zp_m zp_m yp_p avdd sg13_hv_pmos ad=1.125p pd=5u as=1.125p ps=5u w=4.5u l=0.5u
X292 tihi tihi avdd avdd sg13_hv_pmos ad=1.125p pd=5u as=1.125p ps=5u w=4.5u l=9.5u
X293 a_29300_5400# in_m yp_p avss sg13_hv_nmos ad=1.125p pd=5u as=1.125p ps=5u w=4.5u l=0.5u
X294 tihi tihi avdd avdd sg13_hv_pmos ad=1.125p pd=5u as=1.125p ps=5u w=4.5u l=9.5u
X295 a_18900_6600# bnb bnb avss sg13_hv_nmos ad=1.125p pd=5u as=1.125p ps=5u w=4.5u l=0.5u
X296 out zn_p a_57700_6600# avss sg13_hv_nmos ad=1.125p pd=5u as=1.125p ps=5u w=4.5u l=0.5u
X297 a_39700_5400# bnb zp_m avss sg13_hv_nmos ad=1.125p pd=5u as=1.125p ps=5u w=4.5u l=0.5u
X298 yn_m in_p xp avdd sg13_hv_pmos ad=1.125p pd=5u as=1.125p ps=5u w=4.5u l=0.5u
X299 a_51300_6600# zn_m yn_m avss sg13_hv_nmos ad=1.125p pd=5u as=1.125p ps=5u w=4.5u l=0.5u
X300 bnb bnb a_22500_6600# avss sg13_hv_nmos ad=1.125p pd=5u as=1.125p ps=5u w=4.5u l=0.5u
X301 out zp_p avdd avdd sg13_hv_pmos ad=1.125p pd=5u as=1.125p ps=5u w=4.5u l=0.5u
X302 enb en avss avss sg13_hv_nmos ad=1.125p pd=5u as=2.25p ps=10u w=4.5u l=1.5u
X303 zp_m zp_m yp_p avdd sg13_hv_pmos ad=1.125p pd=5u as=1.125p ps=5u w=4.5u l=0.5u
X304 xn in_p a_26900_6600# avss sg13_hv_nmos ad=1.125p pd=5u as=1.125p ps=5u w=4.5u l=0.5u
X305 bpa_l bpb bpb avdd sg13_hv_pmos ad=1.125p pd=5u as=1.125p ps=5u w=4.5u l=0.5u
X306 bpb bpb bpa_r avdd sg13_hv_pmos ad=1.125p pd=5u as=1.125p ps=5u w=4.5u l=0.5u
X307 yp_m zp_m avdd avdd sg13_hv_pmos ad=1.125p pd=5u as=1.125p ps=5u w=4.5u l=3.5u
X308 zn_p zn_m a_53700_5400# avss sg13_hv_nmos ad=1.125p pd=5u as=1.125p ps=5u w=4.5u l=0.5u
X309 a_19300_5400# bnb bna_ avss sg13_hv_nmos ad=1.125p pd=5u as=1.125p ps=5u w=4.5u l=0.5u
X310 avss zn_p a_58100_5400# avss sg13_hv_nmos ad=1.125p pd=5u as=1.125p ps=5u w=4.5u l=0.5u
X311 a_30300_5400# bna xn avss sg13_hv_nmos ad=1.125p pd=5u as=1.125p ps=5u w=4.5u l=3.5u
X312 a_43900_600# bpb zn_m avdd sg13_hv_pmos ad=1.125p pd=5u as=1.125p ps=5u w=4.5u l=0.5u
X313 a_41300_6600# bnb zp_m avss sg13_hv_nmos ad=1.125p pd=5u as=1.125p ps=5u w=4.5u l=0.5u
X314 zn_p bpb zp_p avdd sg13_hv_pmos ad=1.125p pd=5u as=1.125p ps=5u w=4.5u l=0.5u
X315 a_12100_600# bpa_l avdd avdd sg13_hv_pmos ad=1.125p pd=5u as=1.125p ps=5u w=4.5u l=0.5u
X316 bpa en avdd avdd sg13_hv_pmos ad=1.125p pd=5u as=1.125p ps=5u w=4.5u l=1.5u
X317 bna_ bnb a_22900_5400# avss sg13_hv_nmos ad=1.125p pd=5u as=1.125p ps=5u w=4.5u l=0.5u
X318 a_20900_600# bpa_r bpa_r avdd sg13_hv_pmos ad=1.125p pd=5u as=1.125p ps=5u w=4.5u l=0.5u
X319 yp_p zp_m zp_m avdd sg13_hv_pmos ad=1.125p pd=5u as=1.125p ps=5u w=4.5u l=0.5u
X320 a_51700_6600# bnb zn_p avss sg13_hv_nmos ad=1.125p pd=5u as=1.125p ps=5u w=4.5u l=0.5u
X321 yn_m in_p xp avdd sg13_hv_pmos ad=1.125p pd=5u as=1.125p ps=5u w=4.5u l=0.5u
X322 bnb bnb a_16900_6600# avss sg13_hv_nmos ad=1.125p pd=5u as=1.125p ps=5u w=4.5u l=0.5u
X323 a_56100_6600# zn_p avss avss sg13_hv_nmos ad=1.125p pd=5u as=1.125p ps=5u w=4.5u l=0.5u
X324 avss en enb avss sg13_hv_nmos ad=1.125p pd=5u as=1.125p ps=5u w=4.5u l=1.5u
X325 avdd zp_m yp_p avdd sg13_hv_pmos ad=1.125p pd=5u as=1.125p ps=5u w=4.5u l=3.5u
X326 yp_m in_p a_27300_6600# avss sg13_hv_nmos ad=1.125p pd=5u as=1.125p ps=5u w=4.5u l=0.5u
X327 bna enb avss avss sg13_hv_nmos ad=1.125p pd=5u as=1.125p ps=5u w=4.5u l=1.5u
X328 yp_p zp_m avdd avdd sg13_hv_pmos ad=1.125p pd=5u as=1.125p ps=5u w=4.5u l=3.5u
X329 bpa_l bpb bpb avdd sg13_hv_pmos ad=1.125p pd=5u as=1.125p ps=5u w=4.5u l=0.5u
X330 bpa_r bpb bpb avdd sg13_hv_pmos ad=1.125p pd=5u as=1.125p ps=5u w=4.5u l=0.5u
X331 a_19700_5400# bnb bnb avss sg13_hv_nmos ad=1.125p pd=5u as=1.125p ps=5u w=4.5u l=0.5u
X332 out zp_p avdd avdd sg13_hv_pmos ad=1.125p pd=5u as=1.125p ps=5u w=4.5u l=0.5u
X333 out zn_p a_58500_5400# avss sg13_hv_nmos ad=1.125p pd=5u as=1.125p ps=5u w=4.5u l=0.5u
X334 a_31900_6600# zn_m avss avss sg13_hv_nmos ad=1.125p pd=5u as=1.125p ps=5u w=4.5u l=3.5u
X335 xp in_p yn_m avdd sg13_hv_pmos ad=1.125p pd=5u as=1.125p ps=5u w=4.5u l=0.5u
X336 a_52100_5400# bnb zp_p avss sg13_hv_nmos ad=1.125p pd=5u as=1.125p ps=5u w=4.5u l=0.5u
X337 a_57900_600# zp_p out avdd sg13_hv_pmos ad=1.125p pd=5u as=1.125p ps=5u w=4.5u l=0.5u
X338 a_16100_600# bpa_l bpa_l avdd sg13_hv_pmos ad=1.125p pd=5u as=1.125p ps=5u w=4.5u l=0.5u
X339 a_42300_6600# bna a_39100_5400# avss sg13_hv_nmos ad=1.125p pd=5u as=1.125p ps=5u w=4.5u l=3.5u
X340 a_23500_5400# bna_ a_23300_5400# avss sg13_hv_nmos ad=1.125p pd=5u as=1.125p ps=5u w=4.5u l=0.5u
X341 yp_m bpa avdd avdd sg13_hv_pmos ad=1.125p pd=5u as=1.125p ps=5u w=4.5u l=3.5u
X342 a_46100_6600# zn_m zn_m avss sg13_hv_nmos ad=1.125p pd=5u as=1.125p ps=5u w=4.5u l=0.5u
X343 a_4700_5400# bna avss avss sg13_hv_nmos ad=1.125p pd=5u as=1.125p ps=5u w=4.5u l=3.5u
X344 bna_ bnb a_17300_6600# avss sg13_hv_nmos ad=1.125p pd=5u as=1.125p ps=5u w=4.5u l=0.5u
X345 yn_m in_p xp avdd sg13_hv_pmos ad=1.125p pd=5u as=1.125p ps=5u w=4.5u l=0.5u
X346 a_56500_6600# zn_p out avss sg13_hv_nmos ad=1.125p pd=5u as=1.125p ps=5u w=4.5u l=0.5u
X347 xn in_p a_27700_6600# avss sg13_hv_nmos ad=1.125p pd=5u as=1.125p ps=5u w=4.5u l=0.5u
X348 avss enb bna avss sg13_hv_nmos ad=1.125p pd=5u as=1.125p ps=5u w=4.5u l=1.5u
X349 zn_m bpb a_46700_600# avdd sg13_hv_pmos ad=1.125p pd=5u as=1.125p ps=5u w=4.5u l=0.5u
X350 a_21300_6600# bnb bnb avss sg13_hv_nmos ad=1.125p pd=5u as=1.125p ps=5u w=4.5u l=0.5u
X351 zn_m bpb a_43900_600# avdd sg13_hv_pmos ad=1.125p pd=5u as=1.125p ps=5u w=4.5u l=0.5u
X352 bpa_r bpb bpb avdd sg13_hv_pmos ad=1.125p pd=5u as=1.125p ps=5u w=4.5u l=0.5u
X353 out zp_p avdd avdd sg13_hv_pmos ad=1.125p pd=5u as=1.125p ps=5u w=4.5u l=0.5u
X354 xp in_m yn_p avdd sg13_hv_pmos ad=1.125p pd=5u as=1.125p ps=5u w=4.5u l=0.5u
X355 a_12100_1800# bpa_l avdd avdd sg13_hv_pmos ad=1.125p pd=5u as=1.125p ps=5u w=4.5u l=0.5u
X356 yp_m zp_m zp_p avdd sg13_hv_pmos ad=1.125p pd=5u as=1.125p ps=5u w=4.5u l=0.5u
X357 a_36700_6600# zn_m yn_p avss sg13_hv_nmos ad=1.125p pd=5u as=1.125p ps=5u w=4.5u l=3.5u
X358 avdd bpa bpa avdd sg13_hv_pmos ad=1.125p pd=5u as=1.125p ps=5u w=4.5u l=3.5u
X359 a_52500_5400# bnb zn_p avss sg13_hv_nmos ad=1.125p pd=5u as=1.125p ps=5u w=4.5u l=0.5u
X360 avdd bpa bnb avdd sg13_hv_pmos ad=1.125p pd=5u as=1.125p ps=5u w=4.5u l=3.5u
X361 a_23900_5400# bna_ a_23700_5400# avss sg13_hv_nmos ad=1.125p pd=5u as=1.125p ps=5u w=4.5u l=0.5u
X362 avdd zp_m yp_p avdd sg13_hv_pmos ad=1.125p pd=5u as=1.125p ps=5u w=4.5u l=3.5u
X363 a_46500_6600# zn_m yn_p avss sg13_hv_nmos ad=1.125p pd=5u as=1.125p ps=5u w=4.5u l=0.5u
X364 yp_p in_m a_28100_5400# avss sg13_hv_nmos ad=1.125p pd=5u as=1.125p ps=5u w=4.5u l=0.5u
X365 yn_m in_p xp avdd sg13_hv_pmos ad=1.125p pd=5u as=1.125p ps=5u w=4.5u l=0.5u
X366 bnb bnb a_17700_6600# avss sg13_hv_nmos ad=1.125p pd=5u as=1.125p ps=5u w=4.5u l=0.5u
X367 a_56900_6600# zn_p avss avss sg13_hv_nmos ad=1.125p pd=5u as=1.125p ps=5u w=4.5u l=0.5u
X368 a_56300_600# zp_p out avdd sg13_hv_pmos ad=1.125p pd=5u as=1.125p ps=5u w=4.5u l=0.5u
X369 avss bna a_11100_6600# avss sg13_hv_nmos ad=1.125p pd=5u as=1.125p ps=5u w=4.5u l=3.5u
X370 bnb bpa avdd avdd sg13_hv_pmos ad=1.125p pd=5u as=1.125p ps=5u w=4.5u l=3.5u
X371 yn_m zn_m a_31900_5400# avss sg13_hv_nmos ad=1.125p pd=5u as=1.125p ps=5u w=4.5u l=3.5u
X372 zn_m bpb a_46700_600# avdd sg13_hv_pmos ad=1.125p pd=5u as=1.125p ps=5u w=4.5u l=0.5u
X373 a_9500_6600# bna avss avss sg13_hv_nmos ad=1.125p pd=5u as=1.125p ps=5u w=4.5u l=3.5u
X374 a_21700_6600# bnb bna_ avss sg13_hv_nmos ad=1.125p pd=5u as=1.125p ps=5u w=4.5u l=0.5u
X375 bpa_l bpb bpb avdd sg13_hv_pmos ad=1.125p pd=5u as=1.125p ps=5u w=4.5u l=0.5u
X376 avss bna a_42300_5400# avss sg13_hv_nmos ad=1.125p pd=5u as=1.125p ps=5u w=4.5u l=3.5u
X377 yp_m zp_m zp_p avdd sg13_hv_pmos ad=1.125p pd=5u as=1.125p ps=5u w=4.5u l=0.5u
X378 a_12500_1800# bpa_l a_12300_1800# avdd sg13_hv_pmos ad=1.125p pd=5u as=1.125p ps=5u w=4.5u l=0.5u
X379 a_52900_5400# bnb zp_p avss sg13_hv_nmos ad=1.125p pd=5u as=1.125p ps=5u w=4.5u l=0.5u
X380 bna_ bnb a_18100_5400# avss sg13_hv_nmos ad=1.125p pd=5u as=1.125p ps=5u w=4.5u l=0.5u
X381 avdd zp_m yp_m avdd sg13_hv_pmos ad=1.125p pd=5u as=1.125p ps=5u w=4.5u l=3.5u
X382 a_57300_5400# zn_p out avss sg13_hv_nmos ad=1.125p pd=5u as=1.125p ps=5u w=4.5u l=0.5u
X383 a_46900_6600# zn_m zn_m avss sg13_hv_nmos ad=1.125p pd=5u as=1.125p ps=5u w=4.5u l=0.5u
X384 bna bna a_4700_5400# avss sg13_hv_nmos ad=1.125p pd=5u as=1.125p ps=5u w=4.5u l=3.5u
X385 avdd zp_m yp_m avdd sg13_hv_pmos ad=1.125p pd=5u as=1.125p ps=5u w=4.5u l=3.5u
X386 xn in_m a_28500_5400# avss sg13_hv_nmos ad=1.125p pd=5u as=1.125p ps=5u w=4.5u l=0.5u
X387 zp_m bnb a_40100_6600# avss sg13_hv_nmos ad=1.125p pd=5u as=1.125p ps=5u w=4.5u l=0.5u
X388 a_22100_5400# bnb bnb avss sg13_hv_nmos ad=1.125p pd=5u as=1.125p ps=5u w=4.5u l=0.5u
X389 yp_p zp_m avdd avdd sg13_hv_pmos ad=1.125p pd=5u as=1.125p ps=5u w=4.5u l=3.5u
X390 avdd zp_m yp_m avdd sg13_hv_pmos ad=1.125p pd=5u as=1.125p ps=5u w=4.5u l=3.5u
X391 zn_p zn_m a_50500_6600# avss sg13_hv_nmos ad=1.125p pd=5u as=1.125p ps=5u w=4.5u l=0.5u
X392 a_16100_6600# bna_ a_15900_6600# avss sg13_hv_nmos ad=1.125p pd=5u as=1.125p ps=5u w=4.5u l=0.5u
X393 bpa_r bpb bpb avdd sg13_hv_pmos ad=1.125p pd=5u as=1.125p ps=5u w=4.5u l=0.5u
X394 a_26500_6600# in_p xn avss sg13_hv_nmos ad=1.125p pd=5u as=1.125p ps=5u w=4.5u l=0.5u
X395 yp_p zp_m zp_m avdd sg13_hv_pmos ad=1.125p pd=5u as=1.125p ps=5u w=4.5u l=0.5u
X396 avdd zp_m yp_p avdd sg13_hv_pmos ad=1.125p pd=5u as=1.125p ps=5u w=4.5u l=3.5u
X397 bpb bpb bpa_l avdd sg13_hv_pmos ad=1.125p pd=5u as=1.125p ps=5u w=4.5u l=0.5u
X398 a_47900_5400# zn_m yn_p avss sg13_hv_nmos ad=1.125p pd=5u as=1.125p ps=5u w=4.5u l=3.5u
X399 avss zn_m a_36700_6600# avss sg13_hv_nmos ad=1.125p pd=5u as=1.125p ps=5u w=4.5u l=3.5u
X400 bnb bnb a_18500_5400# avss sg13_hv_nmos ad=1.125p pd=5u as=1.125p ps=5u w=4.5u l=0.5u
X401 avdd zp_p out avdd sg13_hv_pmos ad=1.125p pd=5u as=1.125p ps=5u w=4.5u l=0.5u
X402 a_17300_1800# bpa_r a_17100_1800# avdd sg13_hv_pmos ad=1.125p pd=5u as=1.125p ps=5u w=4.5u l=0.5u
X403 a_57700_5400# zn_p avss avss sg13_hv_nmos ad=1.125p pd=5u as=1.125p ps=5u w=4.5u l=0.5u
X404 a_12700_5400# bna avss avss sg13_hv_nmos ad=1.125p pd=5u as=1.125p ps=5u w=4.5u l=3.5u
X405 yp_p zp_m zp_m avdd sg13_hv_pmos ad=1.125p pd=5u as=1.125p ps=5u w=4.5u l=0.5u
X406 yn_m zn_m a_50900_5400# avss sg13_hv_nmos ad=1.125p pd=5u as=1.125p ps=5u w=4.5u l=0.5u
X407 a_39100_5400# bnb a_40500_6600# avss sg13_hv_nmos ad=1.125p pd=5u as=1.125p ps=5u w=4.5u l=0.5u
X408 bpa bna a_9500_5400# avss sg13_hv_nmos ad=1.125p pd=5u as=1.125p ps=5u w=4.5u l=3.5u
X409 a_46700_600# bpb zn_m avdd sg13_hv_pmos ad=1.125p pd=5u as=1.125p ps=5u w=4.5u l=0.5u
X410 a_21100_1800# bpa_r a_20900_1800# avdd sg13_hv_pmos ad=1.125p pd=5u as=1.125p ps=5u w=4.5u l=0.5u
X411 a_22500_5400# bnb bna_ avss sg13_hv_nmos ad=1.125p pd=5u as=1.125p ps=5u w=4.5u l=0.5u
X412 bpb bpb bpa_l avdd sg13_hv_pmos ad=1.125p pd=5u as=1.125p ps=5u w=4.5u l=0.5u
X413 zn_m zn_m a_44900_6600# avss sg13_hv_nmos ad=1.125p pd=5u as=1.125p ps=5u w=4.5u l=0.5u
X414 zp_p zp_m yp_m avdd sg13_hv_pmos ad=1.125p pd=5u as=1.125p ps=5u w=4.5u l=0.5u
X415 a_16500_6600# bna_ a_16300_6600# avss sg13_hv_nmos ad=1.125p pd=5u as=1.125p ps=5u w=4.5u l=0.5u
X416 a_33500_5400# zn_m yn_m avss sg13_hv_nmos ad=1.125p pd=5u as=1.125p ps=5u w=4.5u l=3.5u
X417 yp_p zp_m zp_m avdd sg13_hv_pmos ad=1.125p pd=5u as=1.125p ps=5u w=4.5u l=0.5u
X418 yp_p zp_m zp_m avdd sg13_hv_pmos ad=1.125p pd=5u as=1.125p ps=5u w=4.5u l=0.5u
X419 a_26900_6600# in_p yp_m avss sg13_hv_nmos ad=1.125p pd=5u as=1.125p ps=5u w=4.5u l=0.5u
X420 xp bpa avdd avdd sg13_hv_pmos ad=1.125p pd=5u as=1.125p ps=5u w=4.5u l=3.5u
X421 bnb bnb a_20100_6600# avss sg13_hv_nmos ad=1.125p pd=5u as=1.125p ps=5u w=4.5u l=0.5u
X422 zp_m bnb a_40900_5400# avss sg13_hv_nmos ad=1.125p pd=5u as=1.125p ps=5u w=4.5u l=0.5u
X423 bpb bpb bpa_r avdd sg13_hv_pmos ad=1.125p pd=5u as=1.125p ps=5u w=4.5u l=0.5u
X424 avdd en zp_p avdd sg13_hv_pmos ad=2.25p pd=10u as=1.125p ps=5u w=4.5u l=1.5u
X425 avdd zp_p out avdd sg13_hv_pmos ad=1.125p pd=5u as=1.125p ps=5u w=4.5u l=0.5u
X426 zp_p zp_m yp_m avdd sg13_hv_pmos ad=1.125p pd=5u as=1.125p ps=5u w=4.5u l=0.5u
X427 zn_p zn_m a_51300_5400# avss sg13_hv_nmos ad=1.125p pd=5u as=1.125p ps=5u w=4.5u l=0.5u
X428 a_22900_5400# bnb bnb avss sg13_hv_nmos ad=1.125p pd=5u as=1.125p ps=5u w=4.5u l=0.5u
X429 bpb bpb bpa_r avdd sg13_hv_pmos ad=1.125p pd=5u as=1.125p ps=5u w=4.5u l=0.5u
X430 avdd bpa_r a_21300_1800# avdd sg13_hv_pmos ad=1.125p pd=5u as=1.125p ps=5u w=4.5u l=0.5u
X431 yn_p zn_m a_45300_6600# avss sg13_hv_nmos ad=1.125p pd=5u as=1.125p ps=5u w=4.5u l=0.5u
X432 zp_p bpb zn_p avdd sg13_hv_pmos ad=1.125p pd=5u as=1.125p ps=5u w=4.5u l=0.5u
X433 a_27300_5400# in_p xn avss sg13_hv_nmos ad=1.125p pd=5u as=1.125p ps=5u w=4.5u l=0.5u
X434 a_21100_600# bpa_r a_20900_600# avdd sg13_hv_pmos ad=1.125p pd=5u as=1.125p ps=5u w=4.5u l=0.5u
X435 a_16900_6600# bnb bna_ avss sg13_hv_nmos ad=1.125p pd=5u as=1.125p ps=5u w=4.5u l=0.5u
X436 xp in_m yn_p avdd sg13_hv_pmos ad=1.125p pd=5u as=1.125p ps=5u w=4.5u l=0.5u
X437 a_38300_5400# bna avss avss sg13_hv_nmos ad=1.125p pd=5u as=1.125p ps=5u w=4.5u l=3.5u
X438 bpb bpb bpa_l avdd sg13_hv_pmos ad=1.125p pd=5u as=1.125p ps=5u w=4.5u l=0.5u
X439 bna_ bnb a_20500_6600# avss sg13_hv_nmos ad=1.125p pd=5u as=1.125p ps=5u w=4.5u l=0.5u
X440 zp_m zp_m yp_p avdd sg13_hv_pmos ad=1.125p pd=5u as=1.125p ps=5u w=4.5u l=0.5u
X441 a_39100_5400# bnb a_41300_5400# avss sg13_hv_nmos ad=1.125p pd=5u as=1.125p ps=5u w=4.5u l=0.5u
X442 bpb bna a_12700_5400# avss sg13_hv_nmos ad=1.125p pd=5u as=1.125p ps=5u w=4.5u l=3.5u
X443 zp_p bpb zn_p avdd sg13_hv_pmos ad=1.125p pd=5u as=1.125p ps=5u w=4.5u l=0.5u
X444 zp_p bnb a_51700_5400# avss sg13_hv_nmos ad=1.125p pd=5u as=1.125p ps=5u w=4.5u l=0.5u
X445 a_17300_5400# bnb bnb avss sg13_hv_nmos ad=1.125p pd=5u as=1.125p ps=5u w=4.5u l=0.5u
X446 zp_m zp_m yp_p avdd sg13_hv_pmos ad=1.125p pd=5u as=1.125p ps=5u w=4.5u l=0.5u
X447 out zn_p a_56100_5400# avss sg13_hv_nmos ad=1.125p pd=5u as=1.125p ps=5u w=4.5u l=0.5u
X448 zn_m zn_m a_45700_6600# avss sg13_hv_nmos ad=1.125p pd=5u as=1.125p ps=5u w=4.5u l=0.5u
X449 out zp_p a_57900_600# avdd sg13_hv_pmos ad=1.125p pd=5u as=1.125p ps=5u w=4.5u l=0.5u
X450 a_27700_5400# in_p yp_m avss sg13_hv_nmos ad=1.125p pd=5u as=1.125p ps=5u w=4.5u l=0.5u
X451 bnb bnb a_20900_5400# avss sg13_hv_nmos ad=1.125p pd=5u as=1.125p ps=5u w=4.5u l=0.5u
X452 xp in_m yn_p avdd sg13_hv_pmos ad=1.125p pd=5u as=1.125p ps=5u w=4.5u l=0.5u
X453 a_17300_600# bpa_r a_17100_600# avdd sg13_hv_pmos ad=1.125p pd=5u as=1.125p ps=5u w=4.5u l=0.5u
X454 a_54100_6600# zn_m zn_p avss sg13_hv_nmos ad=1.125p pd=5u as=1.125p ps=5u w=4.5u l=0.5u
X455 yp_p zp_m avdd avdd sg13_hv_pmos ad=1.125p pd=5u as=1.125p ps=5u w=4.5u l=3.5u
X456 bna en ib avss sg13_hv_nmos ad=1.125p pd=5u as=1.125p ps=5u w=4.5u l=1.5u
X457 yp_m zp_m zp_p avdd sg13_hv_pmos ad=1.125p pd=5u as=1.125p ps=5u w=4.5u l=0.5u
X458 bpb bpb bpa_r avdd sg13_hv_pmos ad=1.125p pd=5u as=1.125p ps=5u w=4.5u l=0.5u
X459 zp_p bpb zn_p avdd sg13_hv_pmos ad=1.125p pd=5u as=1.125p ps=5u w=4.5u l=0.5u
X460 yn_p zn_m a_46100_5400# avss sg13_hv_nmos ad=1.125p pd=5u as=1.125p ps=5u w=4.5u l=0.5u
X461 a_16300_1800# bpa_l a_16100_1800# avdd sg13_hv_pmos ad=1.125p pd=5u as=1.125p ps=5u w=4.5u l=0.5u
X462 a_17700_5400# bnb bna_ avss sg13_hv_nmos ad=1.125p pd=5u as=1.125p ps=5u w=4.5u l=0.5u
X463 avdd zp_m yp_m avdd sg13_hv_pmos ad=1.125p pd=5u as=1.125p ps=5u w=4.5u l=3.5u
X464 avss zn_p a_56500_5400# avss sg13_hv_nmos ad=1.125p pd=5u as=1.125p ps=5u w=4.5u l=0.5u
X465 bpa_l bpa_l a_12500_600# avdd sg13_hv_pmos ad=1.125p pd=5u as=1.125p ps=5u w=4.5u l=0.5u
X466 bpb bpb bpa_r avdd sg13_hv_pmos ad=1.125p pd=5u as=1.125p ps=5u w=4.5u l=0.5u
X467 yn_p zn_m a_43900_6600# avss sg13_hv_nmos ad=1.125p pd=5u as=1.125p ps=5u w=4.5u l=3.5u
X468 bna_ bnb a_21300_5400# avss sg13_hv_nmos ad=1.125p pd=5u as=1.125p ps=5u w=4.5u l=0.5u
X469 avdd zp_m yp_p avdd sg13_hv_pmos ad=1.125p pd=5u as=1.125p ps=5u w=4.5u l=3.5u
X470 a_15500_6600# bna_ a_15300_6600# avss sg13_hv_nmos ad=1.125p pd=5u as=1.125p ps=5u w=4.5u l=0.5u
X471 a_55100_6600# zn_m yn_m avss sg13_hv_nmos ad=1.125p pd=5u as=1.125p ps=5u w=4.5u l=3.5u
X472 xp in_p yn_m avdd sg13_hv_pmos ad=1.125p pd=5u as=1.125p ps=5u w=4.5u l=0.5u
X473 a_7100_6600# bna bna avss sg13_hv_nmos ad=1.125p pd=5u as=1.125p ps=5u w=4.5u l=3.5u
X474 avdd zp_p out avdd sg13_hv_pmos ad=1.125p pd=5u as=1.125p ps=5u w=4.5u l=0.5u
X475 avdd bpa a_43900_600# avdd sg13_hv_pmos ad=1.125p pd=5u as=1.125p ps=5u w=4.5u l=3.5u
X476 zn_m zn_m a_46500_5400# avss sg13_hv_nmos ad=1.125p pd=5u as=1.125p ps=5u w=4.5u l=0.5u
X477 avdd bpa_l a_16500_1800# avdd sg13_hv_pmos ad=1.125p pd=5u as=1.125p ps=5u w=4.5u l=0.5u
X478 a_40100_5400# bnb a_39100_5400# avss sg13_hv_nmos ad=1.125p pd=5u as=1.125p ps=5u w=4.5u l=0.5u
X479 zp_p zp_m yp_m avdd sg13_hv_pmos ad=1.125p pd=5u as=1.125p ps=5u w=4.5u l=0.5u
X480 avdd bpa_l a_16500_600# avdd sg13_hv_pmos ad=1.125p pd=5u as=1.125p ps=5u w=4.5u l=0.5u
X481 a_50500_5400# zn_m yn_m avss sg13_hv_nmos ad=1.125p pd=5u as=1.125p ps=5u w=4.5u l=0.5u
X482 bpb bpb bpa_r avdd sg13_hv_pmos ad=1.125p pd=5u as=1.125p ps=5u w=4.5u l=0.5u
X483 bnb bnb a_21700_5400# avss sg13_hv_nmos ad=1.125p pd=5u as=1.125p ps=5u w=4.5u l=0.5u
X484 zn_m bpb a_43900_600# avdd sg13_hv_pmos ad=1.125p pd=5u as=1.125p ps=5u w=4.5u l=0.5u
X485 a_15900_6600# bna_ a_15700_6600# avss sg13_hv_nmos ad=1.125p pd=5u as=1.125p ps=5u w=4.5u l=0.5u
X486 xp in_m yn_p avdd sg13_hv_pmos ad=1.125p pd=5u as=1.125p ps=5u w=4.5u l=0.5u
X487 yn_p in_m xp avdd sg13_hv_pmos ad=1.125p pd=5u as=1.125p ps=5u w=4.5u l=0.5u
X488 zn_p enb avss avss sg13_hv_nmos ad=1.125p pd=5u as=1.125p ps=5u w=4.5u l=1.5u
X489 a_24100_6600# bna_ a_23900_6600# avss sg13_hv_nmos ad=1.125p pd=5u as=1.125p ps=5u w=4.5u l=0.5u
X490 a_40500_5400# bnb zp_m avss sg13_hv_nmos ad=1.125p pd=5u as=1.125p ps=5u w=4.5u l=0.5u
X491 bpa bpa avdd avdd sg13_hv_pmos ad=1.125p pd=5u as=1.125p ps=5u w=4.5u l=3.5u
X492 a_35100_6600# zn_m avss avss sg13_hv_nmos ad=1.125p pd=5u as=1.125p ps=5u w=4.5u l=3.5u
X493 a_50900_5400# zn_m zn_p avss sg13_hv_nmos ad=1.125p pd=5u as=1.125p ps=5u w=4.5u l=0.5u
X494 a_16300_5400# bna_ a_16100_5400# avss sg13_hv_nmos ad=1.125p pd=5u as=1.125p ps=5u w=4.5u l=0.5u
X495 a_20900_1800# bpa_r bpa_r avdd sg13_hv_pmos ad=1.125p pd=5u as=1.125p ps=5u w=4.5u l=0.5u
X496 avss zn_m a_55100_5400# avss sg13_hv_nmos ad=1.125p pd=5u as=1.125p ps=5u w=4.5u l=3.5u
X497 a_44900_6600# zn_m yn_p avss sg13_hv_nmos ad=1.125p pd=5u as=1.125p ps=5u w=4.5u l=0.5u
X498 avdd bpa a_46700_600# avdd sg13_hv_pmos ad=1.125p pd=5u as=1.125p ps=5u w=4.5u l=3.5u
X499 yp_m in_p a_26500_5400# avss sg13_hv_nmos ad=1.125p pd=5u as=1.125p ps=5u w=4.5u l=0.5u
X500 out zp_p avdd avdd sg13_hv_pmos ad=1.125p pd=5u as=1.125p ps=5u w=4.5u l=0.5u
X501 bpa_l bpb bpb avdd sg13_hv_pmos ad=1.125p pd=5u as=1.125p ps=5u w=4.5u l=0.5u
X502 avss bna a_7100_5400# avss sg13_hv_nmos ad=1.125p pd=5u as=1.125p ps=5u w=4.5u l=3.5u
X503 a_20100_5400# bnb bna_ avss sg13_hv_nmos ad=1.125p pd=5u as=1.125p ps=5u w=4.5u l=0.5u
X504 yn_p in_m xp avdd sg13_hv_pmos ad=1.125p pd=5u as=1.125p ps=5u w=4.5u l=0.5u
X505 avss enb zn_p avss sg13_hv_nmos ad=2.25p pd=10u as=1.125p ps=5u w=4.5u l=1.5u
X506 zn_p bnb a_52900_6600# avss sg13_hv_nmos ad=1.125p pd=5u as=1.125p ps=5u w=4.5u l=0.5u
X507 avss bna a_30300_5400# avss sg13_hv_nmos ad=1.125p pd=5u as=1.125p ps=5u w=4.5u l=3.5u
X508 zp_p zp_m yp_m avdd sg13_hv_pmos ad=1.125p pd=5u as=1.125p ps=5u w=4.5u l=0.5u
X509 a_40900_5400# bnb a_39100_5400# avss sg13_hv_nmos ad=1.125p pd=5u as=1.125p ps=5u w=4.5u l=0.5u
X510 a_24500_6600# bna_ a_24300_6600# avss sg13_hv_nmos ad=1.125p pd=5u as=1.125p ps=5u w=4.5u l=0.5u
X511 bpa bpa avdd avdd sg13_hv_pmos ad=1.125p pd=5u as=1.125p ps=5u w=4.5u l=3.5u
X512 a_45300_5400# zn_m zn_m avss sg13_hv_nmos ad=1.125p pd=5u as=1.125p ps=5u w=4.5u l=0.5u
X513 bna_ bna_ a_16500_5400# avss sg13_hv_nmos ad=1.125p pd=5u as=1.125p ps=5u w=4.5u l=0.5u
X514 zn_p bpb zp_p avdd sg13_hv_pmos ad=1.125p pd=5u as=1.125p ps=5u w=4.5u l=0.5u
X515 bpb bpb bpa_l avdd sg13_hv_pmos ad=1.125p pd=5u as=1.125p ps=5u w=4.5u l=0.5u
X516 a_39300_6600# bnb a_39100_5400# avss sg13_hv_nmos ad=1.125p pd=5u as=1.125p ps=5u w=4.5u l=0.5u
X517 yn_p in_m xp avdd sg13_hv_pmos ad=1.125p pd=5u as=1.125p ps=5u w=4.5u l=0.5u
X518 bpa_r bpb bpb avdd sg13_hv_pmos ad=1.125p pd=5u as=1.125p ps=5u w=4.5u l=0.5u
X519 avdd zp_m yp_m avdd sg13_hv_pmos ad=1.125p pd=5u as=1.125p ps=5u w=4.5u l=3.5u
X520 yn_m zn_m a_49500_6600# avss sg13_hv_nmos ad=1.125p pd=5u as=1.125p ps=5u w=4.5u l=3.5u
X521 a_20500_5400# bnb bnb avss sg13_hv_nmos ad=1.125p pd=5u as=1.125p ps=5u w=4.5u l=0.5u
X522 avss bna a_14300_6600# avss sg13_hv_nmos ad=1.125p pd=5u as=1.125p ps=5u w=4.5u l=3.5u
X523 avdd zp_m yp_m avdd sg13_hv_pmos ad=1.125p pd=5u as=1.125p ps=5u w=4.5u l=3.5u
X524 yn_m zn_m a_53300_6600# avss sg13_hv_nmos ad=1.125p pd=5u as=1.125p ps=5u w=4.5u l=0.5u
X525 yn_p zn_m a_35100_5400# avss sg13_hv_nmos ad=1.125p pd=5u as=1.125p ps=5u w=4.5u l=3.5u
X526 a_25500_6600# bna avss avss sg13_hv_nmos ad=1.125p pd=5u as=1.125p ps=5u w=4.5u l=3.5u
X527 a_46700_600# bpb zn_m avdd sg13_hv_pmos ad=1.125p pd=5u as=1.125p ps=5u w=4.5u l=0.5u
X528 a_43900_600# bpb zn_m avdd sg13_hv_pmos ad=1.125p pd=5u as=1.125p ps=5u w=4.5u l=0.5u
X529 a_45700_5400# zn_m yn_p avss sg13_hv_nmos ad=1.125p pd=5u as=1.125p ps=5u w=4.5u l=0.5u
X530 a_29300_6600# in_m yp_p avss sg13_hv_nmos ad=1.125p pd=5u as=1.125p ps=5u w=4.5u l=0.5u
X531 bpb bpb bpa_l avdd sg13_hv_pmos ad=1.125p pd=5u as=1.125p ps=5u w=4.5u l=0.5u
X532 bpb bpb bpa_l avdd sg13_hv_pmos ad=1.125p pd=5u as=1.125p ps=5u w=4.5u l=0.5u
X533 a_39700_6600# bnb zp_m avss sg13_hv_nmos ad=1.125p pd=5u as=1.125p ps=5u w=4.5u l=0.5u
X534 avdd zp_m yp_p avdd sg13_hv_pmos ad=1.125p pd=5u as=1.125p ps=5u w=4.5u l=3.5u
X535 yp_m zp_m zp_p avdd sg13_hv_pmos ad=1.125p pd=5u as=1.125p ps=5u w=4.5u l=0.5u
X536 avdd zp_p out avdd sg13_hv_pmos ad=1.125p pd=5u as=1.125p ps=5u w=4.5u l=0.5u
X537 a_11100_5400# bna bpa avss sg13_hv_nmos ad=1.125p pd=5u as=1.125p ps=5u w=4.5u l=3.5u
X538 zn_p bpb zp_p avdd sg13_hv_pmos ad=1.125p pd=5u as=1.125p ps=5u w=4.5u l=0.5u
X539 a_20900_5400# bnb bna_ avss sg13_hv_nmos ad=1.125p pd=5u as=1.125p ps=5u w=4.5u l=0.5u
X540 zn_p zn_m a_53700_6600# avss sg13_hv_nmos ad=1.125p pd=5u as=1.125p ps=5u w=4.5u l=0.5u
X541 zp_p en avdd avdd sg13_hv_pmos ad=1.125p pd=5u as=1.125p ps=5u w=4.5u l=1.5u
X542 a_19300_6600# bnb bna_ avss sg13_hv_nmos ad=1.125p pd=5u as=1.125p ps=5u w=4.5u l=0.5u
X543 avss zn_p a_58100_6600# avss sg13_hv_nmos ad=1.125p pd=5u as=1.125p ps=5u w=4.5u l=0.5u
X544 a_43900_600# bpb zn_m avdd sg13_hv_pmos ad=1.125p pd=5u as=1.125p ps=5u w=4.5u l=0.5u
X545 a_30300_6600# bna xn avss sg13_hv_nmos ad=1.125p pd=5u as=1.125p ps=5u w=4.5u l=3.5u
X546 bpb bpb bpa_r avdd sg13_hv_pmos ad=1.125p pd=5u as=1.125p ps=5u w=4.5u l=0.5u
X547 bna_ bnb a_22900_6600# avss sg13_hv_nmos ad=1.125p pd=5u as=1.125p ps=5u w=4.5u l=0.5u
X548 yp_m zp_m zp_p avdd sg13_hv_pmos ad=1.125p pd=5u as=1.125p ps=5u w=4.5u l=0.5u
X549 a_15300_5400# bna_ avss avss sg13_hv_nmos ad=1.125p pd=5u as=1.125p ps=5u w=4.5u l=0.5u
X550 bnb bpa avdd avdd sg13_hv_pmos ad=1.125p pd=5u as=1.125p ps=5u w=4.5u l=3.5u
X551 yn_m zn_m a_54100_5400# avss sg13_hv_nmos ad=1.125p pd=5u as=1.125p ps=5u w=4.5u l=0.5u
X552 xn bna a_25500_5400# avss sg13_hv_nmos ad=1.125p pd=5u as=1.125p ps=5u w=4.5u l=3.5u
X553 zn_m bpb a_46700_600# avdd sg13_hv_pmos ad=1.125p pd=5u as=1.125p ps=5u w=4.5u l=0.5u
X554 bpa_l bpb bpb avdd sg13_hv_pmos ad=1.125p pd=5u as=1.125p ps=5u w=4.5u l=0.5u
X555 a_19700_6600# bnb bnb avss sg13_hv_nmos ad=1.125p pd=5u as=1.125p ps=5u w=4.5u l=0.5u
X556 out zn_p a_58500_6600# avss sg13_hv_nmos ad=1.125p pd=5u as=1.125p ps=5u w=4.5u l=0.5u
X557 yp_p zp_m zp_m avdd sg13_hv_pmos ad=1.125p pd=5u as=1.125p ps=5u w=4.5u l=0.5u
X558 zp_m zp_m yp_p avdd sg13_hv_pmos ad=1.125p pd=5u as=1.125p ps=5u w=4.5u l=0.5u
X559 a_52100_6600# bnb zp_p avss sg13_hv_nmos ad=1.125p pd=5u as=1.125p ps=5u w=4.5u l=0.5u
X560 a_23500_6600# bna_ a_23300_6600# avss sg13_hv_nmos ad=1.125p pd=5u as=1.125p ps=5u w=4.5u l=0.5u
X561 a_4700_6600# bna avss avss sg13_hv_nmos ad=1.125p pd=5u as=1.125p ps=5u w=4.5u l=3.5u
X562 xp in_p yn_m avdd sg13_hv_pmos ad=1.125p pd=5u as=1.125p ps=5u w=4.5u l=0.5u
X563 a_58700_600# zp_p out avdd sg13_hv_pmos ad=1.125p pd=5u as=1.125p ps=5u w=4.5u l=0.5u
X564 bpa_l bpb bpb avdd sg13_hv_pmos ad=1.125p pd=5u as=1.125p ps=5u w=4.5u l=0.5u
X565 a_15700_5400# bna_ a_15500_5400# avss sg13_hv_nmos ad=1.125p pd=5u as=1.125p ps=5u w=4.5u l=0.5u
X566 avdd zp_m yp_m avdd sg13_hv_pmos ad=1.125p pd=5u as=1.125p ps=5u w=4.5u l=3.5u
X567 zp_p zp_m yp_m avdd sg13_hv_pmos ad=1.125p pd=5u as=1.125p ps=5u w=4.5u l=0.5u
X568 avss zn_p a_58900_5400# avss sg13_hv_nmos ad=1.125p pd=5u as=1.125p ps=5u w=4.5u l=0.5u
X569 bpa_r bpb bpb avdd sg13_hv_pmos ad=1.125p pd=5u as=1.125p ps=5u w=4.5u l=0.5u
X570 bpb bpb bpa_r avdd sg13_hv_pmos ad=1.125p pd=5u as=1.125p ps=5u w=4.5u l=0.5u
X571 yp_p zp_m zp_m avdd sg13_hv_pmos ad=1.125p pd=5u as=1.125p ps=5u w=4.5u l=0.5u
X572 a_52500_6600# bnb zn_p avss sg13_hv_nmos ad=1.125p pd=5u as=1.125p ps=5u w=4.5u l=0.5u
X573 avdd bpa a_43900_600# avdd sg13_hv_pmos ad=1.125p pd=5u as=1.125p ps=5u w=4.5u l=3.5u
X574 a_12300_600# bpa_l a_12100_600# avdd sg13_hv_pmos ad=1.125p pd=5u as=1.125p ps=5u w=4.5u l=0.5u
X575 yp_m zp_m zp_p avdd sg13_hv_pmos ad=1.125p pd=5u as=1.125p ps=5u w=4.5u l=0.5u
X576 a_23900_6600# bna_ a_23700_6600# avss sg13_hv_nmos ad=1.125p pd=5u as=1.125p ps=5u w=4.5u l=0.5u
X577 a_43900_600# bpa avdd avdd sg13_hv_pmos ad=1.125p pd=5u as=1.125p ps=5u w=4.5u l=3.5u
X578 yp_p in_m a_28100_6600# avss sg13_hv_nmos ad=1.125p pd=5u as=1.125p ps=5u w=4.5u l=0.5u
X579 zp_p zp_m yp_m avdd sg13_hv_pmos ad=1.125p pd=5u as=1.125p ps=5u w=4.5u l=0.5u
X580 bpa_l bpb bpb avdd sg13_hv_pmos ad=1.125p pd=5u as=1.125p ps=5u w=4.5u l=0.5u
X581 yp_p zp_m avdd avdd sg13_hv_pmos ad=1.125p pd=5u as=1.125p ps=5u w=4.5u l=3.5u
X582 bpa_r bpb bpb avdd sg13_hv_pmos ad=1.125p pd=5u as=1.125p ps=5u w=4.5u l=0.5u
X583 out zp_p avdd avdd sg13_hv_pmos ad=1.125p pd=5u as=1.125p ps=5u w=4.5u l=0.5u
X584 yn_m zn_m a_31900_6600# avss sg13_hv_nmos ad=1.125p pd=5u as=1.125p ps=5u w=4.5u l=3.5u
X585 avdd en enb avdd sg13_hv_pmos ad=1.125p pd=5u as=1.125p ps=5u w=4.5u l=1.5u
X586 a_57100_600# zp_p out avdd sg13_hv_pmos ad=1.125p pd=5u as=1.125p ps=5u w=4.5u l=0.5u
X587 avss bna a_42300_6600# avss sg13_hv_nmos ad=1.125p pd=5u as=1.125p ps=5u w=4.5u l=3.5u
X588 yn_m in_p xp avdd sg13_hv_pmos ad=1.125p pd=5u as=1.125p ps=5u w=4.5u l=0.5u
X589 avdd bpa bnb avdd sg13_hv_pmos ad=1.125p pd=5u as=1.125p ps=5u w=4.5u l=3.5u
X590 a_24300_5400# bna_ a_24100_5400# avss sg13_hv_nmos ad=1.125p pd=5u as=1.125p ps=5u w=4.5u l=0.5u
X591 a_52900_6600# bnb zp_p avss sg13_hv_nmos ad=1.125p pd=5u as=1.125p ps=5u w=4.5u l=0.5u
X592 a_16300_600# bpa_l a_16100_600# avdd sg13_hv_pmos ad=1.125p pd=5u as=1.125p ps=5u w=4.5u l=0.5u
X593 yn_m in_p xp avdd sg13_hv_pmos ad=1.125p pd=5u as=1.125p ps=5u w=4.5u l=0.5u
X594 bna_ bnb a_18100_6600# avss sg13_hv_nmos ad=1.125p pd=5u as=1.125p ps=5u w=4.5u l=0.5u
X595 a_57300_6600# zn_p out avss sg13_hv_nmos ad=1.125p pd=5u as=1.125p ps=5u w=4.5u l=0.5u
X596 bna bna a_4700_6600# avss sg13_hv_nmos ad=1.125p pd=5u as=1.125p ps=5u w=4.5u l=3.5u
X597 xn in_m a_28500_6600# avss sg13_hv_nmos ad=1.125p pd=5u as=1.125p ps=5u w=4.5u l=0.5u
X598 avdd bpa a_46700_600# avdd sg13_hv_pmos ad=1.125p pd=5u as=1.125p ps=5u w=4.5u l=3.5u
X599 a_22100_6600# bnb bnb avss sg13_hv_nmos ad=1.125p pd=5u as=1.125p ps=5u w=4.5u l=0.5u
X600 yp_m zp_m avdd avdd sg13_hv_pmos ad=1.125p pd=5u as=1.125p ps=5u w=4.5u l=3.5u
X601 out zp_p avdd avdd sg13_hv_pmos ad=1.125p pd=5u as=1.125p ps=5u w=4.5u l=0.5u
X602 bpa_r bpb bpb avdd sg13_hv_pmos ad=1.125p pd=5u as=1.125p ps=5u w=4.5u l=0.5u
X603 a_43900_600# bpb zn_m avdd sg13_hv_pmos ad=1.125p pd=5u as=1.125p ps=5u w=4.5u l=0.5u
X604 a_53300_5400# zn_m zn_p avss sg13_hv_nmos ad=1.125p pd=5u as=1.125p ps=5u w=4.5u l=0.5u
X605 yp_p zp_m avdd avdd sg13_hv_pmos ad=1.125p pd=5u as=1.125p ps=5u w=4.5u l=3.5u
X606 bnb bpa avdd avdd sg13_hv_pmos ad=1.125p pd=5u as=1.125p ps=5u w=4.5u l=3.5u
X607 avss bna_ a_24500_5400# avss sg13_hv_nmos ad=1.125p pd=5u as=1.125p ps=5u w=4.5u l=0.5u
X608 avdd bpa xp avdd sg13_hv_pmos ad=1.125p pd=5u as=1.125p ps=5u w=4.5u l=3.5u
X609 a_47900_6600# zn_m yn_p avss sg13_hv_nmos ad=1.125p pd=5u as=1.125p ps=5u w=4.5u l=3.5u
X610 yp_p in_m a_28900_5400# avss sg13_hv_nmos ad=1.125p pd=5u as=1.125p ps=5u w=4.5u l=0.5u
X611 avdd bpa xp avdd sg13_hv_pmos ad=1.125p pd=5u as=1.125p ps=5u w=4.5u l=3.5u
X612 bnb bnb a_18500_6600# avss sg13_hv_nmos ad=1.125p pd=5u as=1.125p ps=5u w=4.5u l=0.5u
X613 a_57700_6600# zn_p avss avss sg13_hv_nmos ad=1.125p pd=5u as=1.125p ps=5u w=4.5u l=0.5u
X614 zp_m bnb a_39300_5400# avss sg13_hv_nmos ad=1.125p pd=5u as=1.125p ps=5u w=4.5u l=0.5u
X615 a_12700_6600# bna avss avss sg13_hv_nmos ad=1.125p pd=5u as=1.125p ps=5u w=4.5u l=3.5u
X616 xp bpa avdd avdd sg13_hv_pmos ad=1.125p pd=5u as=1.125p ps=5u w=4.5u l=3.5u
X617 yn_m zn_m a_50900_6600# avss sg13_hv_nmos ad=1.125p pd=5u as=1.125p ps=5u w=4.5u l=0.5u
X618 bpa bna a_9500_6600# avss sg13_hv_nmos ad=1.125p pd=5u as=1.125p ps=5u w=4.5u l=3.5u
X619 out zp_p a_56300_600# avdd sg13_hv_pmos ad=1.125p pd=5u as=1.125p ps=5u w=4.5u l=0.5u
X620 a_22500_6600# bnb bna_ avss sg13_hv_nmos ad=1.125p pd=5u as=1.125p ps=5u w=4.5u l=0.5u
X621 a_43900_5400# zn_m avss avss sg13_hv_nmos ad=1.125p pd=5u as=1.125p ps=5u w=4.5u l=3.5u
X622 bpa_r bpb bpb avdd sg13_hv_pmos ad=1.125p pd=5u as=1.125p ps=5u w=4.5u l=0.5u
X623 out zp_p avdd avdd sg13_hv_pmos ad=1.125p pd=5u as=1.125p ps=5u w=4.5u l=0.5u
X624 a_33500_6600# zn_m yn_m avss sg13_hv_nmos ad=1.125p pd=5u as=1.125p ps=5u w=4.5u l=3.5u
X625 bpb bpb bpa_l avdd sg13_hv_pmos ad=1.125p pd=5u as=1.125p ps=5u w=4.5u l=0.5u
X626 bpb bpb bpa_l avdd sg13_hv_pmos ad=1.125p pd=5u as=1.125p ps=5u w=4.5u l=0.5u
X627 a_53700_5400# zn_m yn_m avss sg13_hv_nmos ad=1.125p pd=5u as=1.125p ps=5u w=4.5u l=0.5u
X628 bna_ bnb a_18900_5400# avss sg13_hv_nmos ad=1.125p pd=5u as=1.125p ps=5u w=4.5u l=0.5u
X629 a_58100_5400# zn_p out avss sg13_hv_nmos ad=1.125p pd=5u as=1.125p ps=5u w=4.5u l=0.5u
X630 ib en bna avss sg13_hv_nmos ad=1.125p pd=5u as=1.125p ps=5u w=4.5u l=1.5u
X631 yp_p zp_m avdd avdd sg13_hv_pmos ad=1.125p pd=5u as=1.125p ps=5u w=4.5u l=3.5u
X632 xn in_m a_29300_5400# avss sg13_hv_nmos ad=1.125p pd=5u as=1.125p ps=5u w=4.5u l=0.5u
X633 zp_m bnb a_40900_6600# avss sg13_hv_nmos ad=1.125p pd=5u as=1.125p ps=5u w=4.5u l=0.5u
X634 avdd tihi tihi avdd sg13_hv_pmos ad=1.125p pd=5u as=1.125p ps=5u w=4.5u l=9.5u
X635 zp_m zp_m yp_p avdd sg13_hv_pmos ad=1.125p pd=5u as=1.125p ps=5u w=4.5u l=0.5u
X636 a_39100_5400# bnb a_39700_5400# avss sg13_hv_nmos ad=1.125p pd=5u as=1.125p ps=5u w=4.5u l=0.5u
X637 yn_p in_m xp avdd sg13_hv_pmos ad=1.125p pd=5u as=1.125p ps=5u w=4.5u l=0.5u
X638 zn_p zn_m a_51300_6600# avss sg13_hv_nmos ad=1.125p pd=5u as=1.125p ps=5u w=4.5u l=0.5u
X639 yp_m zp_m avdd avdd sg13_hv_pmos ad=1.125p pd=5u as=1.125p ps=5u w=4.5u l=3.5u
X640 a_22900_6600# bnb bnb avss sg13_hv_nmos ad=1.125p pd=5u as=1.125p ps=5u w=4.5u l=0.5u
X641 yp_p zp_m zp_m avdd sg13_hv_pmos ad=1.125p pd=5u as=1.125p ps=5u w=4.5u l=0.5u
X642 a_27300_6600# in_p xn avss sg13_hv_nmos ad=1.125p pd=5u as=1.125p ps=5u w=4.5u l=0.5u
X643 bpb bpb bpa_l avdd sg13_hv_pmos ad=1.125p pd=5u as=1.125p ps=5u w=4.5u l=0.5u
X644 avss zn_m a_47900_5400# avss sg13_hv_nmos ad=1.125p pd=5u as=1.125p ps=5u w=4.5u l=3.5u
X645 bpb bpb bpa_r avdd sg13_hv_pmos ad=1.125p pd=5u as=1.125p ps=5u w=4.5u l=0.5u
X646 a_38300_6600# bna avss avss sg13_hv_nmos ad=1.125p pd=5u as=1.125p ps=5u w=4.5u l=3.5u
X647 bnb bnb a_19300_5400# avss sg13_hv_nmos ad=1.125p pd=5u as=1.125p ps=5u w=4.5u l=0.5u
X648 avdd zp_p out avdd sg13_hv_pmos ad=1.125p pd=5u as=1.125p ps=5u w=4.5u l=0.5u
X649 bpb bpb bpa_r avdd sg13_hv_pmos ad=1.125p pd=5u as=1.125p ps=5u w=4.5u l=0.5u
X650 a_58500_5400# zn_p avss avss sg13_hv_nmos ad=1.125p pd=5u as=1.125p ps=5u w=4.5u l=0.5u
X651 a_46700_600# bpb zn_m avdd sg13_hv_pmos ad=1.125p pd=5u as=1.125p ps=5u w=4.5u l=0.5u
X652 a_39100_5400# bnb a_41300_6600# avss sg13_hv_nmos ad=1.125p pd=5u as=1.125p ps=5u w=4.5u l=0.5u
X653 bpb bpb bpa_l avdd sg13_hv_pmos ad=1.125p pd=5u as=1.125p ps=5u w=4.5u l=0.5u
X654 a_23300_5400# bna_ bna_ avss sg13_hv_nmos ad=1.125p pd=5u as=1.125p ps=5u w=4.5u l=0.5u
X655 zp_m zp_m yp_p avdd sg13_hv_pmos ad=1.125p pd=5u as=1.125p ps=5u w=4.5u l=0.5u
X656 bpb bna a_12700_6600# avss sg13_hv_nmos ad=1.125p pd=5u as=1.125p ps=5u w=4.5u l=3.5u
X657 zp_p bnb a_51700_6600# avss sg13_hv_nmos ad=1.125p pd=5u as=1.125p ps=5u w=4.5u l=0.5u
X658 zp_m zp_m yp_p avdd sg13_hv_pmos ad=1.125p pd=5u as=1.125p ps=5u w=4.5u l=0.5u
X659 xp in_p yn_m avdd sg13_hv_pmos ad=1.125p pd=5u as=1.125p ps=5u w=4.5u l=0.5u
X660 a_17300_6600# bnb bnb avss sg13_hv_nmos ad=1.125p pd=5u as=1.125p ps=5u w=4.5u l=0.5u
X661 avss zn_m a_33500_5400# avss sg13_hv_nmos ad=1.125p pd=5u as=1.125p ps=5u w=4.5u l=3.5u
X662 out zn_p a_56100_6600# avss sg13_hv_nmos ad=1.125p pd=5u as=1.125p ps=5u w=4.5u l=0.5u
X663 zn_p bpb zp_p avdd sg13_hv_pmos ad=1.125p pd=5u as=1.125p ps=5u w=4.5u l=0.5u
.ends

.subckt lpopamp_sliceA in_m in_p out avss avdd ib en zp_p zn_p
X0 xp bpa avdd avdd sg13_hv_pmos ad=1.125p pd=5u as=1.125p ps=5u w=4.5u l=3.5u
X1 zp_p bpb zn_p avdd sg13_hv_pmos ad=1.125p pd=5u as=1.125p ps=5u w=4.5u l=0.5u
X2 a_16300_5000# bpa_l a_16100_5000# avdd sg13_hv_pmos ad=1.125p pd=5u as=1.125p ps=5u w=4.5u l=0.5u
X3 a_15700_1400# bna_ a_15500_1400# avss sg13_hv_nmos ad=1.125p pd=5u as=1.125p ps=5u w=4.5u l=0.5u
X4 a_39700_200# bnb zp_m avss sg13_hv_nmos ad=1.125p pd=5u as=1.125p ps=5u w=4.5u l=0.5u
X5 avdd zp_m yp_m avdd sg13_hv_pmos ad=1.125p pd=5u as=1.125p ps=5u w=4.5u l=3.5u
X6 zn_m bpb a_43900_5000# avdd sg13_hv_pmos ad=1.125p pd=5u as=1.125p ps=5u w=4.5u l=0.5u
X7 avss zn_p a_58900_1400# avss sg13_hv_nmos ad=1.125p pd=5u as=1.125p ps=5u w=4.5u l=0.5u
X8 zn_p zn_m a_50500_200# avss sg13_hv_nmos ad=1.125p pd=5u as=1.125p ps=5u w=4.5u l=0.5u
X9 bpb bpb bpa_r avdd sg13_hv_pmos ad=1.125p pd=5u as=1.125p ps=5u w=4.5u l=0.5u
X10 avdd en zp_p avdd sg13_hv_pmos ad=2.25p pd=10u as=1.125p ps=5u w=4.5u l=1.5u
X11 bpb bpb bpa_l avdd sg13_hv_pmos ad=1.125p pd=5u as=1.125p ps=5u w=4.5u l=0.5u
X12 avdd bpa yp_m avdd sg13_hv_pmos ad=1.125p pd=5u as=1.125p ps=5u w=4.5u l=3.5u
X13 zn_p enb avss avss sg13_hv_nmos ad=1.125p pd=5u as=1.125p ps=5u w=4.5u l=1.5u
X14 avdd bpa a_43900_5000# avdd sg13_hv_pmos ad=1.125p pd=5u as=1.125p ps=5u w=4.5u l=3.5u
X15 a_18500_200# bnb bna_ avss sg13_hv_nmos ad=1.125p pd=5u as=1.125p ps=5u w=4.5u l=0.5u
X16 avdd bpa_l a_16500_5000# avdd sg13_hv_pmos ad=1.125p pd=5u as=1.125p ps=5u w=4.5u l=0.5u
X17 zp_m zp_m yp_p avdd sg13_hv_pmos ad=1.125p pd=5u as=1.125p ps=5u w=4.5u l=0.5u
X18 zp_p zp_m yp_m avdd sg13_hv_pmos ad=1.125p pd=5u as=1.125p ps=5u w=4.5u l=0.5u
X19 bpb bpb bpa_r avdd sg13_hv_pmos ad=1.125p pd=5u as=1.125p ps=5u w=4.5u l=0.5u
X20 a_21700_200# bnb bna_ avss sg13_hv_nmos ad=1.125p pd=5u as=1.125p ps=5u w=4.5u l=0.5u
X21 a_46900_200# zn_m zn_m avss sg13_hv_nmos ad=1.125p pd=5u as=1.125p ps=5u w=4.5u l=0.5u
X22 a_24300_1400# bna_ a_24100_1400# avss sg13_hv_nmos ad=1.125p pd=5u as=1.125p ps=5u w=4.5u l=0.5u
X23 bpb bpb bpa_l avdd sg13_hv_pmos ad=1.125p pd=5u as=1.125p ps=5u w=4.5u l=0.5u
X24 yp_m zp_m zp_p avdd sg13_hv_pmos ad=1.125p pd=5u as=1.125p ps=5u w=4.5u l=0.5u
X25 yn_m in_p xp avdd sg13_hv_pmos ad=1.125p pd=5u as=1.125p ps=5u w=4.5u l=0.5u
X26 yp_p zp_m avdd avdd sg13_hv_pmos ad=1.125p pd=5u as=1.125p ps=5u w=4.5u l=3.5u
X27 a_41300_200# bnb zp_m avss sg13_hv_nmos ad=1.125p pd=5u as=1.125p ps=5u w=4.5u l=0.5u
X28 avdd zp_m yp_p avdd sg13_hv_pmos ad=1.125p pd=5u as=1.125p ps=5u w=4.5u l=3.5u
X29 xp in_m yn_p avdd sg13_hv_pmos ad=1.125p pd=5u as=1.125p ps=5u w=4.5u l=0.5u
X30 bpa bpa avdd avdd sg13_hv_pmos ad=1.125p pd=5u as=1.125p ps=5u w=4.5u l=3.5u
X31 out zn_p a_58500_200# avss sg13_hv_nmos ad=1.125p pd=5u as=1.125p ps=5u w=4.5u l=0.5u
X32 xn bna a_25500_200# avss sg13_hv_nmos ad=1.125p pd=5u as=1.125p ps=5u w=4.5u l=3.5u
X33 a_53300_1400# zn_m zn_p avss sg13_hv_nmos ad=1.125p pd=5u as=1.125p ps=5u w=4.5u l=0.5u
X34 a_20900_5000# bpa_r bpa_r avdd sg13_hv_pmos ad=1.125p pd=5u as=1.125p ps=5u w=4.5u l=0.5u
X35 avss bna_ a_24500_1400# avss sg13_hv_nmos ad=1.125p pd=5u as=1.125p ps=5u w=4.5u l=0.5u
X36 bnb bnb a_17700_200# avss sg13_hv_nmos ad=1.125p pd=5u as=1.125p ps=5u w=4.5u l=0.5u
X37 yp_m in_p a_28900_1400# avss sg13_hv_nmos ad=1.125p pd=5u as=1.125p ps=5u w=4.5u l=0.5u
X38 bpb bpb bpa_l avdd sg13_hv_pmos ad=1.125p pd=5u as=1.125p ps=5u w=4.5u l=0.5u
X39 zn_p bpb zp_p avdd sg13_hv_pmos ad=1.125p pd=5u as=1.125p ps=5u w=4.5u l=0.5u
X40 zn_p bnb a_52900_200# avss sg13_hv_nmos ad=1.125p pd=5u as=1.125p ps=5u w=4.5u l=0.5u
X41 bpb bpb bpa_r avdd sg13_hv_pmos ad=1.125p pd=5u as=1.125p ps=5u w=4.5u l=0.5u
X42 yn_m in_p xp avdd sg13_hv_pmos ad=1.125p pd=5u as=1.125p ps=5u w=4.5u l=0.5u
X43 a_20100_200# bnb bna_ avss sg13_hv_nmos ad=1.125p pd=5u as=1.125p ps=5u w=4.5u l=0.5u
X44 avdd zp_p out avdd sg13_hv_pmos ad=1.125p pd=5u as=1.125p ps=5u w=4.5u l=0.5u
X45 zp_m bnb a_39300_1400# avss sg13_hv_nmos ad=1.125p pd=5u as=1.125p ps=5u w=4.5u l=0.5u
X46 yp_m zp_m avdd avdd sg13_hv_pmos ad=1.125p pd=5u as=1.125p ps=5u w=4.5u l=3.5u
X47 a_45300_200# zn_m zn_m avss sg13_hv_nmos ad=1.125p pd=5u as=1.125p ps=5u w=4.5u l=0.5u
X48 a_43900_1400# zn_m avss avss sg13_hv_nmos ad=1.125p pd=5u as=1.125p ps=5u w=4.5u l=3.5u
X49 xp in_m yn_p avdd sg13_hv_pmos ad=1.125p pd=5u as=1.125p ps=5u w=4.5u l=0.5u
X50 bpb bpb bpa_l avdd sg13_hv_pmos ad=1.125p pd=5u as=1.125p ps=5u w=4.5u l=0.5u
X51 a_30300_200# bna xn avss sg13_hv_nmos ad=1.125p pd=5u as=1.125p ps=5u w=4.5u l=3.5u
X52 a_53700_1400# zn_m yn_m avss sg13_hv_nmos ad=1.125p pd=5u as=1.125p ps=5u w=4.5u l=0.5u
X53 zn_p bpb zp_p avdd sg13_hv_pmos ad=1.125p pd=5u as=1.125p ps=5u w=4.5u l=0.5u
X54 bna_ bnb a_18900_1400# avss sg13_hv_nmos ad=1.125p pd=5u as=1.125p ps=5u w=4.5u l=0.5u
X55 a_58100_1400# zn_p out avss sg13_hv_nmos ad=1.125p pd=5u as=1.125p ps=5u w=4.5u l=0.5u
X56 avdd zp_m yp_p avdd sg13_hv_pmos ad=1.125p pd=5u as=1.125p ps=5u w=4.5u l=3.5u
X57 a_39100_200# bnb a_40500_200# avss sg13_hv_nmos ad=1.125p pd=5u as=1.125p ps=5u w=4.5u l=0.5u
X58 avss en enb avss sg13_hv_nmos ad=1.125p pd=5u as=1.125p ps=5u w=4.5u l=1.5u
X59 ib en bna avss sg13_hv_nmos ad=1.125p pd=5u as=1.125p ps=5u w=4.5u l=1.5u
X60 out zn_p a_56900_200# avss sg13_hv_nmos ad=1.125p pd=5u as=1.125p ps=5u w=4.5u l=0.5u
X61 xn in_p a_29300_1400# avss sg13_hv_nmos ad=1.125p pd=5u as=1.125p ps=5u w=4.5u l=0.5u
X62 a_24100_200# bna_ a_23900_200# avss sg13_hv_nmos ad=1.125p pd=5u as=1.125p ps=5u w=4.5u l=0.5u
X63 bpb bpb bpa_r avdd sg13_hv_pmos ad=1.125p pd=5u as=1.125p ps=5u w=4.5u l=0.5u
X64 a_58700_6200# zp_p out avdd sg13_hv_pmos ad=1.125p pd=5u as=1.125p ps=5u w=4.5u l=0.5u
X65 a_33500_200# zn_m yn_p avss sg13_hv_nmos ad=1.125p pd=5u as=1.125p ps=5u w=4.5u l=3.5u
X66 bpa_l bpb bpb avdd sg13_hv_pmos ad=1.125p pd=5u as=1.125p ps=5u w=4.5u l=0.5u
X67 a_39100_200# bnb a_39700_1400# avss sg13_hv_nmos ad=1.125p pd=5u as=1.125p ps=5u w=4.5u l=0.5u
X68 a_16300_200# bna_ a_16100_200# avss sg13_hv_nmos ad=1.125p pd=5u as=1.125p ps=5u w=4.5u l=0.5u
X69 tihi tihi avdd avdd sg13_hv_pmos ad=1.125p pd=5u as=1.125p ps=5u w=4.5u l=9.5u
X70 a_43900_5000# bpb zn_m avdd sg13_hv_pmos ad=1.125p pd=5u as=1.125p ps=5u w=4.5u l=0.5u
X71 avss zn_m a_47900_1400# avss sg13_hv_nmos ad=1.125p pd=5u as=1.125p ps=5u w=4.5u l=3.5u
X72 bpb bpb bpa_l avdd sg13_hv_pmos ad=1.125p pd=5u as=1.125p ps=5u w=4.5u l=0.5u
X73 a_52500_200# bnb zn_p avss sg13_hv_nmos ad=1.125p pd=5u as=1.125p ps=5u w=4.5u l=0.5u
X74 bnb bnb a_19300_1400# avss sg13_hv_nmos ad=1.125p pd=5u as=1.125p ps=5u w=4.5u l=0.5u
X75 yp_m zp_m zp_p avdd sg13_hv_pmos ad=1.125p pd=5u as=1.125p ps=5u w=4.5u l=0.5u
X76 a_58500_1400# zn_p avss avss sg13_hv_nmos ad=1.125p pd=5u as=1.125p ps=5u w=4.5u l=0.5u
X77 avdd zp_p out avdd sg13_hv_pmos ad=1.125p pd=5u as=1.125p ps=5u w=4.5u l=0.5u
X78 zp_m zp_m yp_p avdd sg13_hv_pmos ad=1.125p pd=5u as=1.125p ps=5u w=4.5u l=0.5u
X79 a_28100_200# in_p xn avss sg13_hv_nmos ad=1.125p pd=5u as=1.125p ps=5u w=4.5u l=0.5u
X80 a_23300_1400# bna_ bna_ avss sg13_hv_nmos ad=1.125p pd=5u as=1.125p ps=5u w=4.5u l=0.5u
X81 avss zn_m a_36700_200# avss sg13_hv_nmos ad=1.125p pd=5u as=1.125p ps=5u w=4.5u l=3.5u
X82 bpa_l bpb bpb avdd sg13_hv_pmos ad=1.125p pd=5u as=1.125p ps=5u w=4.5u l=0.5u
X83 yp_m zp_m avdd avdd sg13_hv_pmos ad=1.125p pd=5u as=1.125p ps=5u w=4.5u l=3.5u
X84 avss zn_m a_33500_1400# avss sg13_hv_nmos ad=1.125p pd=5u as=1.125p ps=5u w=4.5u l=3.5u
X85 a_43900_5000# bpb zn_m avdd sg13_hv_pmos ad=1.125p pd=5u as=1.125p ps=5u w=4.5u l=0.5u
X86 a_31900_200# zn_m avss avss sg13_hv_nmos ad=1.125p pd=5u as=1.125p ps=5u w=4.5u l=3.5u
X87 a_56500_200# zn_p out avss sg13_hv_nmos ad=1.125p pd=5u as=1.125p ps=5u w=4.5u l=0.5u
X88 yp_p zp_m zp_m avdd sg13_hv_pmos ad=1.125p pd=5u as=1.125p ps=5u w=4.5u l=0.5u
X89 a_23500_200# bna_ a_23300_200# avss sg13_hv_nmos ad=1.125p pd=5u as=1.125p ps=5u w=4.5u l=0.5u
X90 a_58900_1400# zn_p out avss sg13_hv_nmos ad=1.125p pd=5u as=1.125p ps=5u w=4.5u l=0.5u
X91 bna_ bnb a_19700_1400# avss sg13_hv_nmos ad=1.125p pd=5u as=1.125p ps=5u w=4.5u l=0.5u
X92 yn_p in_m xp avdd sg13_hv_pmos ad=1.125p pd=5u as=1.125p ps=5u w=4.5u l=0.5u
X93 a_15700_200# bna_ a_15500_200# avss sg13_hv_nmos ad=1.125p pd=5u as=1.125p ps=5u w=4.5u l=0.5u
X94 zn_p bnb a_52100_1400# avss sg13_hv_nmos ad=1.125p pd=5u as=1.125p ps=5u w=4.5u l=0.5u
X95 avdd zp_m yp_p avdd sg13_hv_pmos ad=1.125p pd=5u as=1.125p ps=5u w=4.5u l=3.5u
X96 a_23700_1400# bna_ a_23500_1400# avss sg13_hv_nmos ad=1.125p pd=5u as=1.125p ps=5u w=4.5u l=0.5u
X97 bpa_l bpb bpb avdd sg13_hv_pmos ad=1.125p pd=5u as=1.125p ps=5u w=4.5u l=0.5u
X98 a_28100_1400# in_p xn avss sg13_hv_nmos ad=1.125p pd=5u as=1.125p ps=5u w=4.5u l=0.5u
X99 zp_p bnb a_51700_200# avss sg13_hv_nmos ad=1.125p pd=5u as=1.125p ps=5u w=4.5u l=0.5u
X100 bna en ib avss sg13_hv_nmos ad=1.125p pd=5u as=1.125p ps=5u w=4.5u l=1.5u
X101 bpa_r bpb bpb avdd sg13_hv_pmos ad=1.125p pd=5u as=1.125p ps=5u w=4.5u l=0.5u
X102 out zp_p a_57100_6200# avdd sg13_hv_pmos ad=1.125p pd=5u as=1.125p ps=5u w=4.5u l=0.5u
X103 yp_p zp_m zp_m avdd sg13_hv_pmos ad=1.125p pd=5u as=1.125p ps=5u w=4.5u l=0.5u
X104 a_39100_200# bna a_38300_1400# avss sg13_hv_nmos ad=1.125p pd=5u as=1.125p ps=5u w=4.5u l=3.5u
X105 yn_m zn_m a_35100_200# avss sg13_hv_nmos ad=1.125p pd=5u as=1.125p ps=5u w=4.5u l=3.5u
X106 a_49500_1400# zn_m avss avss sg13_hv_nmos ad=1.125p pd=5u as=1.125p ps=5u w=4.5u l=3.5u
X107 yp_p in_m a_27300_200# avss sg13_hv_nmos ad=1.125p pd=5u as=1.125p ps=5u w=4.5u l=0.5u
X108 yn_p in_m xp avdd sg13_hv_pmos ad=1.125p pd=5u as=1.125p ps=5u w=4.5u l=0.5u
X109 bpa_l bpb bpb avdd sg13_hv_pmos ad=1.125p pd=5u as=1.125p ps=5u w=4.5u l=0.5u
X110 a_14300_1400# bna bpb avss sg13_hv_nmos ad=1.125p pd=5u as=1.125p ps=5u w=4.5u l=3.5u
X111 a_19700_200# bnb bnb avss sg13_hv_nmos ad=1.125p pd=5u as=1.125p ps=5u w=4.5u l=0.5u
X112 zp_p bnb a_52500_1400# avss sg13_hv_nmos ad=1.125p pd=5u as=1.125p ps=5u w=4.5u l=0.5u
X113 zp_p zp_m yp_m avdd sg13_hv_pmos ad=1.125p pd=5u as=1.125p ps=5u w=4.5u l=0.5u
X114 out zn_p a_56900_1400# avss sg13_hv_nmos ad=1.125p pd=5u as=1.125p ps=5u w=4.5u l=0.5u
X115 a_18100_1400# bnb bnb avss sg13_hv_nmos ad=1.125p pd=5u as=1.125p ps=5u w=4.5u l=0.5u
X116 zn_m bpb a_46700_5000# avdd sg13_hv_pmos ad=1.125p pd=5u as=1.125p ps=5u w=4.5u l=0.5u
X117 a_28500_1400# in_p yp_m avss sg13_hv_nmos ad=1.125p pd=5u as=1.125p ps=5u w=4.5u l=0.5u
X118 yn_p zn_m a_46900_200# avss sg13_hv_nmos ad=1.125p pd=5u as=1.125p ps=5u w=4.5u l=0.5u
X119 bpa_r bpb bpb avdd sg13_hv_pmos ad=1.125p pd=5u as=1.125p ps=5u w=4.5u l=0.5u
X120 out zp_p avdd avdd sg13_hv_pmos ad=1.125p pd=5u as=1.125p ps=5u w=4.5u l=0.5u
X121 a_22900_200# bnb bnb avss sg13_hv_nmos ad=1.125p pd=5u as=1.125p ps=5u w=4.5u l=0.5u
X122 a_12100_6200# bpa_l avdd avdd sg13_hv_pmos ad=1.125p pd=5u as=1.125p ps=5u w=4.5u l=0.5u
X123 yp_p zp_m zp_m avdd sg13_hv_pmos ad=1.125p pd=5u as=1.125p ps=5u w=4.5u l=0.5u
X124 a_39300_200# bnb a_39100_200# avss sg13_hv_nmos ad=1.125p pd=5u as=1.125p ps=5u w=4.5u l=0.5u
X125 yp_m zp_m zp_p avdd sg13_hv_pmos ad=1.125p pd=5u as=1.125p ps=5u w=4.5u l=0.5u
X126 avdd bpa bpa avdd sg13_hv_pmos ad=1.125p pd=5u as=1.125p ps=5u w=4.5u l=3.5u
X127 yp_m zp_m zp_p avdd sg13_hv_pmos ad=1.125p pd=5u as=1.125p ps=5u w=4.5u l=0.5u
X128 avdd bpa bnb avdd sg13_hv_pmos ad=1.125p pd=5u as=1.125p ps=5u w=4.5u l=3.5u
X129 a_43900_5000# bpa avdd avdd sg13_hv_pmos ad=1.125p pd=5u as=1.125p ps=5u w=4.5u l=3.5u
X130 yn_p in_m xp avdd sg13_hv_pmos ad=1.125p pd=5u as=1.125p ps=5u w=4.5u l=0.5u
X131 avss bna a_42300_200# avss sg13_hv_nmos ad=1.125p pd=5u as=1.125p ps=5u w=4.5u l=3.5u
X132 yn_p zn_m a_46900_1400# avss sg13_hv_nmos ad=1.125p pd=5u as=1.125p ps=5u w=4.5u l=0.5u
X133 bpa_l bpb bpb avdd sg13_hv_pmos ad=1.125p pd=5u as=1.125p ps=5u w=4.5u l=0.5u
X134 zp_p zp_m yp_m avdd sg13_hv_pmos ad=1.125p pd=5u as=1.125p ps=5u w=4.5u l=0.5u
X135 bpa_r bpb bpb avdd sg13_hv_pmos ad=1.125p pd=5u as=1.125p ps=5u w=4.5u l=0.5u
X136 a_18500_1400# bnb bna_ avss sg13_hv_nmos ad=1.125p pd=5u as=1.125p ps=5u w=4.5u l=0.5u
X137 avss zn_p a_57300_1400# avss sg13_hv_nmos ad=1.125p pd=5u as=1.125p ps=5u w=4.5u l=0.5u
X138 out zp_p avdd avdd sg13_hv_pmos ad=1.125p pd=5u as=1.125p ps=5u w=4.5u l=0.5u
X139 zn_m bpb a_46700_5000# avdd sg13_hv_pmos ad=1.125p pd=5u as=1.125p ps=5u w=4.5u l=0.5u
X140 a_28900_1400# in_p xn avss sg13_hv_nmos ad=1.125p pd=5u as=1.125p ps=5u w=4.5u l=0.5u
X141 a_18100_200# bnb bnb avss sg13_hv_nmos ad=1.125p pd=5u as=1.125p ps=5u w=4.5u l=0.5u
X142 a_26900_200# in_m yp_p avss sg13_hv_nmos ad=1.125p pd=5u as=1.125p ps=5u w=4.5u l=0.5u
X143 bna_ bnb a_22100_1400# avss sg13_hv_nmos ad=1.125p pd=5u as=1.125p ps=5u w=4.5u l=0.5u
X144 a_12500_6200# bpa_l a_12300_6200# avdd sg13_hv_pmos ad=1.125p pd=5u as=1.125p ps=5u w=4.5u l=0.5u
X145 yp_m zp_m zp_p avdd sg13_hv_pmos ad=1.125p pd=5u as=1.125p ps=5u w=4.5u l=0.5u
X146 yn_p in_m xp avdd sg13_hv_pmos ad=1.125p pd=5u as=1.125p ps=5u w=4.5u l=0.5u
X147 yn_m zn_m a_54100_200# avss sg13_hv_nmos ad=1.125p pd=5u as=1.125p ps=5u w=4.5u l=0.5u
X148 a_21300_200# bnb bnb avss sg13_hv_nmos ad=1.125p pd=5u as=1.125p ps=5u w=4.5u l=0.5u
X149 avdd zp_m yp_p avdd sg13_hv_pmos ad=1.125p pd=5u as=1.125p ps=5u w=4.5u l=3.5u
X150 avdd bpa a_46700_5000# avdd sg13_hv_pmos ad=1.125p pd=5u as=1.125p ps=5u w=4.5u l=3.5u
X151 a_46500_200# zn_m yn_p avss sg13_hv_nmos ad=1.125p pd=5u as=1.125p ps=5u w=4.5u l=0.5u
X152 yp_p zp_m avdd avdd sg13_hv_pmos ad=1.125p pd=5u as=1.125p ps=5u w=4.5u l=3.5u
X153 a_18900_1400# bnb bnb avss sg13_hv_nmos ad=1.125p pd=5u as=1.125p ps=5u w=4.5u l=0.5u
X154 bpa_r bpb bpb avdd sg13_hv_pmos ad=1.125p pd=5u as=1.125p ps=5u w=4.5u l=0.5u
X155 out zn_p a_57700_1400# avss sg13_hv_nmos ad=1.125p pd=5u as=1.125p ps=5u w=4.5u l=0.5u
X156 out zp_p avdd avdd sg13_hv_pmos ad=1.125p pd=5u as=1.125p ps=5u w=4.5u l=0.5u
X157 a_51300_1400# zn_m yn_m avss sg13_hv_nmos ad=1.125p pd=5u as=1.125p ps=5u w=4.5u l=0.5u
X158 yp_p zp_m zp_m avdd sg13_hv_pmos ad=1.125p pd=5u as=1.125p ps=5u w=4.5u l=0.5u
X159 bnb bpa avdd avdd sg13_hv_pmos ad=1.125p pd=5u as=1.125p ps=5u w=4.5u l=3.5u
X160 bnb bnb a_22500_1400# avss sg13_hv_nmos ad=1.125p pd=5u as=1.125p ps=5u w=4.5u l=0.5u
X161 enb en avss avss sg13_hv_nmos ad=1.125p pd=5u as=2.25p ps=10u w=4.5u l=1.5u
X162 bpb bpb bpa_l avdd sg13_hv_pmos ad=1.125p pd=5u as=1.125p ps=5u w=4.5u l=0.5u
X163 xn in_m a_26900_1400# avss sg13_hv_nmos ad=1.125p pd=5u as=1.125p ps=5u w=4.5u l=0.5u
X164 a_17300_6200# bpa_r a_17100_6200# avdd sg13_hv_pmos ad=1.125p pd=5u as=1.125p ps=5u w=4.5u l=0.5u
X165 avdd bpa xp avdd sg13_hv_pmos ad=1.125p pd=5u as=1.125p ps=5u w=4.5u l=3.5u
X166 a_56300_6200# zp_p out avdd sg13_hv_pmos ad=1.125p pd=5u as=1.125p ps=5u w=4.5u l=0.5u
X167 bna bna a_4700_200# avss sg13_hv_nmos ad=1.125p pd=5u as=1.125p ps=5u w=4.5u l=3.5u
X168 avss zn_p a_58100_200# avss sg13_hv_nmos ad=1.125p pd=5u as=1.125p ps=5u w=4.5u l=0.5u
X169 a_21100_6200# bpa_r a_20900_6200# avdd sg13_hv_pmos ad=1.125p pd=5u as=1.125p ps=5u w=4.5u l=0.5u
X170 bna_ bnb a_17300_200# avss sg13_hv_nmos ad=1.125p pd=5u as=1.125p ps=5u w=4.5u l=0.5u
X171 a_41300_1400# bnb zp_m avss sg13_hv_nmos ad=1.125p pd=5u as=1.125p ps=5u w=4.5u l=0.5u
X172 bpa_r bpb bpb avdd sg13_hv_pmos ad=1.125p pd=5u as=1.125p ps=5u w=4.5u l=0.5u
X173 out zp_p avdd avdd sg13_hv_pmos ad=1.125p pd=5u as=1.125p ps=5u w=4.5u l=0.5u
X174 bpb bpb bpa_l avdd sg13_hv_pmos ad=1.125p pd=5u as=1.125p ps=5u w=4.5u l=0.5u
X175 a_51700_1400# bnb zn_p avss sg13_hv_nmos ad=1.125p pd=5u as=1.125p ps=5u w=4.5u l=0.5u
X176 bnb bnb a_16900_1400# avss sg13_hv_nmos ad=1.125p pd=5u as=1.125p ps=5u w=4.5u l=0.5u
X177 yp_p zp_m zp_m avdd sg13_hv_pmos ad=1.125p pd=5u as=1.125p ps=5u w=4.5u l=0.5u
X178 a_53700_200# zn_m yn_m avss sg13_hv_nmos ad=1.125p pd=5u as=1.125p ps=5u w=4.5u l=0.5u
X179 a_56100_1400# zn_p avss avss sg13_hv_nmos ad=1.125p pd=5u as=1.125p ps=5u w=4.5u l=0.5u
X180 bna_ bnb a_20500_200# avss sg13_hv_nmos ad=1.125p pd=5u as=1.125p ps=5u w=4.5u l=0.5u
X181 avss en enb avss sg13_hv_nmos ad=1.125p pd=5u as=1.125p ps=5u w=4.5u l=1.5u
X182 yp_m zp_m avdd avdd sg13_hv_pmos ad=1.125p pd=5u as=1.125p ps=5u w=4.5u l=3.5u
X183 yp_p in_m a_27300_1400# avss sg13_hv_nmos ad=1.125p pd=5u as=1.125p ps=5u w=4.5u l=0.5u
X184 zn_m zn_m a_45700_200# avss sg13_hv_nmos ad=1.125p pd=5u as=1.125p ps=5u w=4.5u l=0.5u
X185 bna enb avss avss sg13_hv_nmos ad=1.125p pd=5u as=1.125p ps=5u w=4.5u l=1.5u
X186 bpb bpb bpa_r avdd sg13_hv_pmos ad=1.125p pd=5u as=1.125p ps=5u w=4.5u l=0.5u
X187 avdd zp_p out avdd sg13_hv_pmos ad=1.125p pd=5u as=1.125p ps=5u w=4.5u l=0.5u
X188 bpb bna a_12700_200# avss sg13_hv_nmos ad=1.125p pd=5u as=1.125p ps=5u w=4.5u l=3.5u
X189 a_9500_200# bna avss avss sg13_hv_nmos ad=1.125p pd=5u as=1.125p ps=5u w=4.5u l=3.5u
X190 zp_m zp_m yp_p avdd sg13_hv_pmos ad=1.125p pd=5u as=1.125p ps=5u w=4.5u l=0.5u
X191 zp_p zp_m yp_m avdd sg13_hv_pmos ad=1.125p pd=5u as=1.125p ps=5u w=4.5u l=0.5u
X192 a_29300_200# in_p yp_m avss sg13_hv_nmos ad=1.125p pd=5u as=1.125p ps=5u w=4.5u l=0.5u
X193 a_31900_1400# zn_m avss avss sg13_hv_nmos ad=1.125p pd=5u as=1.125p ps=5u w=4.5u l=3.5u
X194 avdd bpa_r a_21300_6200# avdd sg13_hv_pmos ad=1.125p pd=5u as=1.125p ps=5u w=4.5u l=0.5u
X195 yp_m zp_m avdd avdd sg13_hv_pmos ad=1.125p pd=5u as=1.125p ps=5u w=4.5u l=3.5u
X196 zp_m bnb a_40100_200# avss sg13_hv_nmos ad=1.125p pd=5u as=1.125p ps=5u w=4.5u l=0.5u
X197 enb en avss avss sg13_hv_nmos ad=1.125p pd=5u as=2.25p ps=10u w=4.5u l=1.5u
X198 yp_p zp_m zp_m avdd sg13_hv_pmos ad=1.125p pd=5u as=1.125p ps=5u w=4.5u l=0.5u
X199 a_42300_1400# bna a_39100_200# avss sg13_hv_nmos ad=1.125p pd=5u as=1.125p ps=5u w=4.5u l=3.5u
X200 a_46100_1400# zn_m zn_m avss sg13_hv_nmos ad=1.125p pd=5u as=1.125p ps=5u w=4.5u l=0.5u
X201 bpb bpb bpa_l avdd sg13_hv_pmos ad=1.125p pd=5u as=1.125p ps=5u w=4.5u l=0.5u
X202 xp in_p yn_m avdd sg13_hv_pmos ad=1.125p pd=5u as=1.125p ps=5u w=4.5u l=0.5u
X203 bna_ bnb a_17300_1400# avss sg13_hv_nmos ad=1.125p pd=5u as=1.125p ps=5u w=4.5u l=0.5u
X204 bpb bpb bpa_r avdd sg13_hv_pmos ad=1.125p pd=5u as=1.125p ps=5u w=4.5u l=0.5u
X205 a_57700_200# zn_p avss avss sg13_hv_nmos ad=1.125p pd=5u as=1.125p ps=5u w=4.5u l=0.5u
X206 a_56500_1400# zn_p out avss sg13_hv_nmos ad=1.125p pd=5u as=1.125p ps=5u w=4.5u l=0.5u
X207 avdd zp_p out avdd sg13_hv_pmos ad=1.125p pd=5u as=1.125p ps=5u w=4.5u l=0.5u
X208 avss bna_ a_24500_200# avss sg13_hv_nmos ad=1.125p pd=5u as=1.125p ps=5u w=4.5u l=0.5u
X209 xn in_m a_27700_1400# avss sg13_hv_nmos ad=1.125p pd=5u as=1.125p ps=5u w=4.5u l=0.5u
X210 avss enb bna avss sg13_hv_nmos ad=1.125p pd=5u as=1.125p ps=5u w=4.5u l=1.5u
X211 a_21300_1400# bnb bnb avss sg13_hv_nmos ad=1.125p pd=5u as=1.125p ps=5u w=4.5u l=0.5u
X212 a_16900_200# bnb bna_ avss sg13_hv_nmos ad=1.125p pd=5u as=1.125p ps=5u w=4.5u l=0.5u
X213 zp_m zp_m yp_p avdd sg13_hv_pmos ad=1.125p pd=5u as=1.125p ps=5u w=4.5u l=0.5u
X214 a_52100_200# bnb zp_p avss sg13_hv_nmos ad=1.125p pd=5u as=1.125p ps=5u w=4.5u l=0.5u
X215 zp_p bpb zn_p avdd sg13_hv_pmos ad=1.125p pd=5u as=1.125p ps=5u w=4.5u l=0.5u
X216 xp in_m yn_p avdd sg13_hv_pmos ad=1.125p pd=5u as=1.125p ps=5u w=4.5u l=0.5u
X217 avss bna a_7100_200# avss sg13_hv_nmos ad=1.125p pd=5u as=1.125p ps=5u w=4.5u l=3.5u
X218 a_36700_1400# zn_m yn_m avss sg13_hv_nmos ad=1.125p pd=5u as=1.125p ps=5u w=4.5u l=3.5u
X219 avss bna a_11100_200# avss sg13_hv_nmos ad=1.125p pd=5u as=1.125p ps=5u w=4.5u l=3.5u
X220 a_46500_1400# zn_m yn_p avss sg13_hv_nmos ad=1.125p pd=5u as=1.125p ps=5u w=4.5u l=0.5u
X221 a_46700_5000# bpb zn_m avdd sg13_hv_pmos ad=1.125p pd=5u as=1.125p ps=5u w=4.5u l=0.5u
X222 xp in_p yn_m avdd sg13_hv_pmos ad=1.125p pd=5u as=1.125p ps=5u w=4.5u l=0.5u
X223 bpb bpb bpa_r avdd sg13_hv_pmos ad=1.125p pd=5u as=1.125p ps=5u w=4.5u l=0.5u
X224 a_56900_1400# zn_p avss avss sg13_hv_nmos ad=1.125p pd=5u as=1.125p ps=5u w=4.5u l=0.5u
X225 bnb bnb a_17700_1400# avss sg13_hv_nmos ad=1.125p pd=5u as=1.125p ps=5u w=4.5u l=0.5u
X226 avdd zp_p out avdd sg13_hv_pmos ad=1.125p pd=5u as=1.125p ps=5u w=4.5u l=0.5u
X227 xn in_p a_28500_200# avss sg13_hv_nmos ad=1.125p pd=5u as=1.125p ps=5u w=4.5u l=0.5u
X228 avss bna a_11100_1400# avss sg13_hv_nmos ad=1.125p pd=5u as=1.125p ps=5u w=4.5u l=3.5u
X229 avdd zp_m yp_m avdd sg13_hv_pmos ad=1.125p pd=5u as=1.125p ps=5u w=4.5u l=3.5u
X230 yp_p zp_m avdd avdd sg13_hv_pmos ad=1.125p pd=5u as=1.125p ps=5u w=4.5u l=3.5u
X231 a_9500_1400# bna avss avss sg13_hv_nmos ad=1.125p pd=5u as=1.125p ps=5u w=4.5u l=3.5u
X232 a_21700_1400# bnb bna_ avss sg13_hv_nmos ad=1.125p pd=5u as=1.125p ps=5u w=4.5u l=0.5u
X233 a_56100_200# zn_p avss avss sg13_hv_nmos ad=1.125p pd=5u as=1.125p ps=5u w=4.5u l=0.5u
X234 zp_p bpb zn_p avdd sg13_hv_pmos ad=1.125p pd=5u as=1.125p ps=5u w=4.5u l=0.5u
X235 bna_ bnb a_22900_200# avss sg13_hv_nmos ad=1.125p pd=5u as=1.125p ps=5u w=4.5u l=0.5u
X236 a_16300_6200# bpa_l a_16100_6200# avdd sg13_hv_pmos ad=1.125p pd=5u as=1.125p ps=5u w=4.5u l=0.5u
X237 xp in_m yn_p avdd sg13_hv_pmos ad=1.125p pd=5u as=1.125p ps=5u w=4.5u l=0.5u
X238 avdd zp_m yp_m avdd sg13_hv_pmos ad=1.125p pd=5u as=1.125p ps=5u w=4.5u l=3.5u
X239 a_15300_200# bna_ avss avss sg13_hv_nmos ad=1.125p pd=5u as=1.125p ps=5u w=4.5u l=0.5u
X240 a_46900_1400# zn_m zn_m avss sg13_hv_nmos ad=1.125p pd=5u as=1.125p ps=5u w=4.5u l=0.5u
X241 a_46700_5000# bpb zn_m avdd sg13_hv_pmos ad=1.125p pd=5u as=1.125p ps=5u w=4.5u l=0.5u
X242 bpb bpb bpa_r avdd sg13_hv_pmos ad=1.125p pd=5u as=1.125p ps=5u w=4.5u l=0.5u
X243 bpb bpb bpa_r avdd sg13_hv_pmos ad=1.125p pd=5u as=1.125p ps=5u w=4.5u l=0.5u
X244 zp_m bnb a_40100_1400# avss sg13_hv_nmos ad=1.125p pd=5u as=1.125p ps=5u w=4.5u l=0.5u
X245 zn_p zn_m a_51300_200# avss sg13_hv_nmos ad=1.125p pd=5u as=1.125p ps=5u w=4.5u l=0.5u
X246 avdd zp_p out avdd sg13_hv_pmos ad=1.125p pd=5u as=1.125p ps=5u w=4.5u l=0.5u
X247 avdd bpa yp_m avdd sg13_hv_pmos ad=1.125p pd=5u as=1.125p ps=5u w=4.5u l=3.5u
X248 a_12300_5000# bpa_l a_12100_5000# avdd sg13_hv_pmos ad=1.125p pd=5u as=1.125p ps=5u w=4.5u l=0.5u
X249 zn_p zn_m a_50500_1400# avss sg13_hv_nmos ad=1.125p pd=5u as=1.125p ps=5u w=4.5u l=0.5u
X250 zp_p zp_m yp_m avdd sg13_hv_pmos ad=1.125p pd=5u as=1.125p ps=5u w=4.5u l=0.5u
X251 a_16100_1400# bna_ a_15900_1400# avss sg13_hv_nmos ad=1.125p pd=5u as=1.125p ps=5u w=4.5u l=0.5u
X252 avdd bpa a_43900_5000# avdd sg13_hv_pmos ad=1.125p pd=5u as=1.125p ps=5u w=4.5u l=3.5u
X253 enb en avdd avdd sg13_hv_pmos ad=1.125p pd=5u as=2.25p ps=10u w=4.5u l=1.5u
X254 xn in_m a_26900_200# avss sg13_hv_nmos ad=1.125p pd=5u as=1.125p ps=5u w=4.5u l=0.5u
X255 a_26500_1400# in_m xn avss sg13_hv_nmos ad=1.125p pd=5u as=1.125p ps=5u w=4.5u l=0.5u
X256 avdd bpa_l a_16500_6200# avdd sg13_hv_pmos ad=1.125p pd=5u as=1.125p ps=5u w=4.5u l=0.5u
X257 avss zn_m a_36700_1400# avss sg13_hv_nmos ad=1.125p pd=5u as=1.125p ps=5u w=4.5u l=3.5u
X258 a_19300_200# bnb bna_ avss sg13_hv_nmos ad=1.125p pd=5u as=1.125p ps=5u w=4.5u l=0.5u
X259 bpb bpb bpa_r avdd sg13_hv_pmos ad=1.125p pd=5u as=1.125p ps=5u w=4.5u l=0.5u
X260 a_46700_5000# bpb zn_m avdd sg13_hv_pmos ad=1.125p pd=5u as=1.125p ps=5u w=4.5u l=0.5u
X261 a_39100_200# bnb a_40500_1400# avss sg13_hv_nmos ad=1.125p pd=5u as=1.125p ps=5u w=4.5u l=0.5u
X262 zp_m zp_m yp_p avdd sg13_hv_pmos ad=1.125p pd=5u as=1.125p ps=5u w=4.5u l=0.5u
X263 zn_m zn_m a_44900_1400# avss sg13_hv_nmos ad=1.125p pd=5u as=1.125p ps=5u w=4.5u l=0.5u
X264 bpa_l bpa_l a_12500_5000# avdd sg13_hv_pmos ad=1.125p pd=5u as=1.125p ps=5u w=4.5u l=0.5u
X265 a_22500_200# bnb bna_ avss sg13_hv_nmos ad=1.125p pd=5u as=1.125p ps=5u w=4.5u l=0.5u
X266 avdd zp_m yp_m avdd sg13_hv_pmos ad=1.125p pd=5u as=1.125p ps=5u w=4.5u l=3.5u
X267 yn_m in_p xp avdd sg13_hv_pmos ad=1.125p pd=5u as=1.125p ps=5u w=4.5u l=0.5u
X268 a_17100_5000# bpa_r a_16900_5000# avdd sg13_hv_pmos ad=1.125p pd=5u as=1.125p ps=5u w=4.5u l=0.5u
X269 a_16500_1400# bna_ a_16300_1400# avss sg13_hv_nmos ad=1.125p pd=5u as=1.125p ps=5u w=4.5u l=0.5u
X270 out zp_p avdd avdd sg13_hv_pmos ad=1.125p pd=5u as=1.125p ps=5u w=4.5u l=0.5u
X271 avdd en enb avdd sg13_hv_pmos ad=1.125p pd=5u as=1.125p ps=5u w=4.5u l=1.5u
X272 a_26900_1400# in_m yp_p avss sg13_hv_nmos ad=1.125p pd=5u as=1.125p ps=5u w=4.5u l=0.5u
X273 bpa en avdd avdd sg13_hv_pmos ad=1.125p pd=5u as=1.125p ps=5u w=4.5u l=1.5u
X274 a_39100_200# bnb a_39700_200# avss sg13_hv_nmos ad=1.125p pd=5u as=1.125p ps=5u w=4.5u l=0.5u
X275 bnb bnb a_20100_1400# avss sg13_hv_nmos ad=1.125p pd=5u as=1.125p ps=5u w=4.5u l=0.5u
X276 bpa bpa avdd avdd sg13_hv_pmos ad=1.125p pd=5u as=1.125p ps=5u w=4.5u l=3.5u
X277 a_50900_200# zn_m zn_p avss sg13_hv_nmos ad=1.125p pd=5u as=1.125p ps=5u w=4.5u l=0.5u
X278 xp bpa avdd avdd sg13_hv_pmos ad=1.125p pd=5u as=1.125p ps=5u w=4.5u l=3.5u
X279 a_20900_6200# bpa_r bpa_r avdd sg13_hv_pmos ad=1.125p pd=5u as=1.125p ps=5u w=4.5u l=0.5u
X280 zp_m zp_m yp_p avdd sg13_hv_pmos ad=1.125p pd=5u as=1.125p ps=5u w=4.5u l=0.5u
X281 a_46700_5000# bpa avdd avdd sg13_hv_pmos ad=1.125p pd=5u as=1.125p ps=5u w=4.5u l=3.5u
X282 yn_p zn_m a_45300_1400# avss sg13_hv_nmos ad=1.125p pd=5u as=1.125p ps=5u w=4.5u l=0.5u
X283 a_26500_200# in_m xn avss sg13_hv_nmos ad=1.125p pd=5u as=1.125p ps=5u w=4.5u l=0.5u
X284 yn_m in_p xp avdd sg13_hv_pmos ad=1.125p pd=5u as=1.125p ps=5u w=4.5u l=0.5u
X285 a_16900_1400# bnb bna_ avss sg13_hv_nmos ad=1.125p pd=5u as=1.125p ps=5u w=4.5u l=0.5u
X286 bpa_r bpa_r a_17300_5000# avdd sg13_hv_pmos ad=1.125p pd=5u as=1.125p ps=5u w=4.5u l=0.5u
X287 out zp_p avdd avdd sg13_hv_pmos ad=1.125p pd=5u as=1.125p ps=5u w=4.5u l=0.5u
X288 bnb bnb a_18500_200# avss sg13_hv_nmos ad=1.125p pd=5u as=1.125p ps=5u w=4.5u l=0.5u
X289 avdd en bpa avdd sg13_hv_pmos ad=1.125p pd=5u as=1.125p ps=5u w=4.5u l=1.5u
X290 a_21300_5000# bpa_r a_21100_5000# avdd sg13_hv_pmos ad=1.125p pd=5u as=1.125p ps=5u w=4.5u l=0.5u
X291 bna_ bnb a_20500_1400# avss sg13_hv_nmos ad=1.125p pd=5u as=1.125p ps=5u w=4.5u l=0.5u
X292 a_46100_200# zn_m zn_m avss sg13_hv_nmos ad=1.125p pd=5u as=1.125p ps=5u w=4.5u l=0.5u
X293 bpb bpb bpa_l avdd sg13_hv_pmos ad=1.125p pd=5u as=1.125p ps=5u w=4.5u l=0.5u
X294 bnb bnb a_21700_200# avss sg13_hv_nmos ad=1.125p pd=5u as=1.125p ps=5u w=4.5u l=0.5u
X295 zn_p bpb zp_p avdd sg13_hv_pmos ad=1.125p pd=5u as=1.125p ps=5u w=4.5u l=0.5u
X296 yn_m in_p xp avdd sg13_hv_pmos ad=1.125p pd=5u as=1.125p ps=5u w=4.5u l=0.5u
X297 avdd zp_m yp_p avdd sg13_hv_pmos ad=1.125p pd=5u as=1.125p ps=5u w=4.5u l=3.5u
X298 zn_m zn_m a_45700_1400# avss sg13_hv_nmos ad=1.125p pd=5u as=1.125p ps=5u w=4.5u l=0.5u
X299 bpa_r bpb bpb avdd sg13_hv_pmos ad=1.125p pd=5u as=1.125p ps=5u w=4.5u l=0.5u
X300 a_39100_200# bnb a_41300_200# avss sg13_hv_nmos ad=1.125p pd=5u as=1.125p ps=5u w=4.5u l=0.5u
X301 out zp_p avdd avdd sg13_hv_pmos ad=1.125p pd=5u as=1.125p ps=5u w=4.5u l=0.5u
X302 avdd bpa bpa avdd sg13_hv_pmos ad=1.125p pd=5u as=1.125p ps=5u w=4.5u l=3.5u
X303 zn_p bpb zp_p avdd sg13_hv_pmos ad=1.125p pd=5u as=1.125p ps=5u w=4.5u l=0.5u
X304 bpa bpa avdd avdd sg13_hv_pmos ad=1.125p pd=5u as=1.125p ps=5u w=4.5u l=3.5u
X305 avss zn_m a_33500_200# avss sg13_hv_nmos ad=1.125p pd=5u as=1.125p ps=5u w=4.5u l=3.5u
X306 a_54100_1400# zn_m zn_p avss sg13_hv_nmos ad=1.125p pd=5u as=1.125p ps=5u w=4.5u l=0.5u
X307 bnb bpa avdd avdd sg13_hv_pmos ad=1.125p pd=5u as=1.125p ps=5u w=4.5u l=3.5u
X308 a_43900_5000# bpb zn_m avdd sg13_hv_pmos ad=1.125p pd=5u as=1.125p ps=5u w=4.5u l=0.5u
X309 a_58900_200# zn_p out avss sg13_hv_nmos ad=1.125p pd=5u as=1.125p ps=5u w=4.5u l=0.5u
X310 bnb bnb a_16900_200# avss sg13_hv_nmos ad=1.125p pd=5u as=1.125p ps=5u w=4.5u l=0.5u
X311 bna en ib avss sg13_hv_nmos ad=1.125p pd=5u as=1.125p ps=5u w=4.5u l=1.5u
X312 bpb bpb bpa_l avdd sg13_hv_pmos ad=1.125p pd=5u as=1.125p ps=5u w=4.5u l=0.5u
X313 yp_m zp_m zp_p avdd sg13_hv_pmos ad=1.125p pd=5u as=1.125p ps=5u w=4.5u l=0.5u
X314 yn_m in_p xp avdd sg13_hv_pmos ad=1.125p pd=5u as=1.125p ps=5u w=4.5u l=0.5u
X315 avdd zp_p out avdd sg13_hv_pmos ad=1.125p pd=5u as=1.125p ps=5u w=4.5u l=0.5u
X316 zn_m bpb a_46700_5000# avdd sg13_hv_pmos ad=1.125p pd=5u as=1.125p ps=5u w=4.5u l=0.5u
X317 a_53300_200# zn_m zn_p avss sg13_hv_nmos ad=1.125p pd=5u as=1.125p ps=5u w=4.5u l=0.5u
X318 bnb bnb a_20100_200# avss sg13_hv_nmos ad=1.125p pd=5u as=1.125p ps=5u w=4.5u l=0.5u
X319 yn_p zn_m a_45300_200# avss sg13_hv_nmos ad=1.125p pd=5u as=1.125p ps=5u w=4.5u l=0.5u
X320 yn_p zn_m a_43900_1400# avss sg13_hv_nmos ad=1.125p pd=5u as=1.125p ps=5u w=4.5u l=3.5u
X321 avss enb bna avss sg13_hv_nmos ad=1.125p pd=5u as=1.125p ps=5u w=4.5u l=1.5u
X322 zn_p bpb zp_p avdd sg13_hv_pmos ad=1.125p pd=5u as=1.125p ps=5u w=4.5u l=0.5u
X323 a_16100_5000# bpa_l bpa_l avdd sg13_hv_pmos ad=1.125p pd=5u as=1.125p ps=5u w=4.5u l=0.5u
X324 a_55100_1400# zn_m yn_m avss sg13_hv_nmos ad=1.125p pd=5u as=1.125p ps=5u w=4.5u l=3.5u
X325 a_15500_1400# bna_ a_15300_1400# avss sg13_hv_nmos ad=1.125p pd=5u as=1.125p ps=5u w=4.5u l=0.5u
X326 a_38300_200# bna avss avss sg13_hv_nmos ad=1.125p pd=5u as=1.125p ps=5u w=4.5u l=3.5u
X327 yp_m zp_m zp_p avdd sg13_hv_pmos ad=1.125p pd=5u as=1.125p ps=5u w=4.5u l=0.5u
X328 a_43900_5000# bpb zn_m avdd sg13_hv_pmos ad=1.125p pd=5u as=1.125p ps=5u w=4.5u l=0.5u
X329 yp_p zp_m avdd avdd sg13_hv_pmos ad=1.125p pd=5u as=1.125p ps=5u w=4.5u l=3.5u
X330 a_7100_1400# bna bna avss sg13_hv_nmos ad=1.125p pd=5u as=1.125p ps=5u w=4.5u l=3.5u
X331 avdd bpa xp avdd sg13_hv_pmos ad=1.125p pd=5u as=1.125p ps=5u w=4.5u l=3.5u
X332 yn_p zn_m a_31900_200# avss sg13_hv_nmos ad=1.125p pd=5u as=1.125p ps=5u w=4.5u l=3.5u
X333 a_40900_200# bnb a_39100_200# avss sg13_hv_nmos ad=1.125p pd=5u as=1.125p ps=5u w=4.5u l=0.5u
X334 a_57300_200# zn_p out avss sg13_hv_nmos ad=1.125p pd=5u as=1.125p ps=5u w=4.5u l=0.5u
X335 a_24300_200# bna_ a_24100_200# avss sg13_hv_nmos ad=1.125p pd=5u as=1.125p ps=5u w=4.5u l=0.5u
X336 a_43900_5000# bpb zn_m avdd sg13_hv_pmos ad=1.125p pd=5u as=1.125p ps=5u w=4.5u l=0.5u
X337 a_16500_200# bna_ a_16300_200# avss sg13_hv_nmos ad=1.125p pd=5u as=1.125p ps=5u w=4.5u l=0.5u
X338 a_16500_5000# bpa_l a_16300_5000# avdd sg13_hv_pmos ad=1.125p pd=5u as=1.125p ps=5u w=4.5u l=0.5u
X339 a_15900_1400# bna_ a_15700_1400# avss sg13_hv_nmos ad=1.125p pd=5u as=1.125p ps=5u w=4.5u l=0.5u
X340 yp_p zp_m zp_m avdd sg13_hv_pmos ad=1.125p pd=5u as=1.125p ps=5u w=4.5u l=0.5u
X341 zn_p enb avss avss sg13_hv_nmos ad=1.125p pd=5u as=1.125p ps=5u w=4.5u l=1.5u
X342 zp_p bnb a_52500_200# avss sg13_hv_nmos ad=1.125p pd=5u as=1.125p ps=5u w=4.5u l=0.5u
X343 bpa_r bpb bpb avdd sg13_hv_pmos ad=1.125p pd=5u as=1.125p ps=5u w=4.5u l=0.5u
X344 a_36700_200# zn_m yn_m avss sg13_hv_nmos ad=1.125p pd=5u as=1.125p ps=5u w=4.5u l=3.5u
X345 a_24100_1400# bna_ a_23900_1400# avss sg13_hv_nmos ad=1.125p pd=5u as=1.125p ps=5u w=4.5u l=0.5u
X346 a_44900_200# zn_m yn_p avss sg13_hv_nmos ad=1.125p pd=5u as=1.125p ps=5u w=4.5u l=0.5u
X347 bpa_l bpb bpb avdd sg13_hv_pmos ad=1.125p pd=5u as=1.125p ps=5u w=4.5u l=0.5u
X348 zp_p zp_m yp_m avdd sg13_hv_pmos ad=1.125p pd=5u as=1.125p ps=5u w=4.5u l=0.5u
X349 yp_m in_p a_28100_200# avss sg13_hv_nmos ad=1.125p pd=5u as=1.125p ps=5u w=4.5u l=0.5u
X350 a_35100_1400# zn_m avss avss sg13_hv_nmos ad=1.125p pd=5u as=1.125p ps=5u w=4.5u l=3.5u
X351 a_44900_1400# zn_m yn_p avss sg13_hv_nmos ad=1.125p pd=5u as=1.125p ps=5u w=4.5u l=0.5u
X352 yp_p zp_m zp_m avdd sg13_hv_pmos ad=1.125p pd=5u as=1.125p ps=5u w=4.5u l=0.5u
X353 a_16900_5000# bpa_r avdd avdd sg13_hv_pmos ad=1.125p pd=5u as=1.125p ps=5u w=4.5u l=0.5u
X354 avss enb zn_p avss sg13_hv_nmos ad=2.25p pd=10u as=1.125p ps=5u w=4.5u l=1.5u
X355 yp_m zp_m zp_p avdd sg13_hv_pmos ad=1.125p pd=5u as=1.125p ps=5u w=4.5u l=0.5u
X356 avss zn_p a_56500_200# avss sg13_hv_nmos ad=1.125p pd=5u as=1.125p ps=5u w=4.5u l=0.5u
X357 zn_p bnb a_52900_1400# avss sg13_hv_nmos ad=1.125p pd=5u as=1.125p ps=5u w=4.5u l=0.5u
X358 bpa_r bpb bpb avdd sg13_hv_pmos ad=1.125p pd=5u as=1.125p ps=5u w=4.5u l=0.5u
X359 a_23700_200# bna_ a_23500_200# avss sg13_hv_nmos ad=1.125p pd=5u as=1.125p ps=5u w=4.5u l=0.5u
X360 a_43900_5000# bpa avdd avdd sg13_hv_pmos ad=1.125p pd=5u as=1.125p ps=5u w=4.5u l=3.5u
X361 a_49500_200# zn_m avss avss sg13_hv_nmos ad=1.125p pd=5u as=1.125p ps=5u w=4.5u l=3.5u
X362 a_24500_1400# bna_ a_24300_1400# avss sg13_hv_nmos ad=1.125p pd=5u as=1.125p ps=5u w=4.5u l=0.5u
X363 bpa_l bpb bpb avdd sg13_hv_pmos ad=1.125p pd=5u as=1.125p ps=5u w=4.5u l=0.5u
X364 a_15900_200# bna_ a_15700_200# avss sg13_hv_nmos ad=1.125p pd=5u as=1.125p ps=5u w=4.5u l=0.5u
X365 zp_p zp_m yp_m avdd sg13_hv_pmos ad=1.125p pd=5u as=1.125p ps=5u w=4.5u l=0.5u
X366 yn_m zn_m a_50900_200# avss sg13_hv_nmos ad=1.125p pd=5u as=1.125p ps=5u w=4.5u l=0.5u
X367 bpa_r bpb bpb avdd sg13_hv_pmos ad=1.125p pd=5u as=1.125p ps=5u w=4.5u l=0.5u
X368 xp in_p yn_m avdd sg13_hv_pmos ad=1.125p pd=5u as=1.125p ps=5u w=4.5u l=0.5u
X369 out zp_p a_57900_6200# avdd sg13_hv_pmos ad=1.125p pd=5u as=1.125p ps=5u w=4.5u l=0.5u
X370 a_39300_1400# bnb a_39100_200# avss sg13_hv_nmos ad=1.125p pd=5u as=1.125p ps=5u w=4.5u l=0.5u
X371 a_43900_200# zn_m avss avss sg13_hv_nmos ad=1.125p pd=5u as=1.125p ps=5u w=4.5u l=3.5u
X372 yn_m zn_m a_49500_1400# avss sg13_hv_nmos ad=1.125p pd=5u as=1.125p ps=5u w=4.5u l=3.5u
X373 yn_p in_m xp avdd sg13_hv_pmos ad=1.125p pd=5u as=1.125p ps=5u w=4.5u l=0.5u
X374 bpa_l bpb bpb avdd sg13_hv_pmos ad=1.125p pd=5u as=1.125p ps=5u w=4.5u l=0.5u
X375 avss bna a_14300_1400# avss sg13_hv_nmos ad=1.125p pd=5u as=1.125p ps=5u w=4.5u l=3.5u
X376 a_27700_200# in_m yp_p avss sg13_hv_nmos ad=1.125p pd=5u as=1.125p ps=5u w=4.5u l=0.5u
X377 yn_m zn_m a_53300_1400# avss sg13_hv_nmos ad=1.125p pd=5u as=1.125p ps=5u w=4.5u l=0.5u
X378 zp_p bpb zn_p avdd sg13_hv_pmos ad=1.125p pd=5u as=1.125p ps=5u w=4.5u l=0.5u
X379 a_25500_1400# bna avss avss sg13_hv_nmos ad=1.125p pd=5u as=1.125p ps=5u w=4.5u l=3.5u
X380 avdd bpa a_46700_5000# avdd sg13_hv_pmos ad=1.125p pd=5u as=1.125p ps=5u w=4.5u l=3.5u
X381 avdd tihi tihi avdd sg13_hv_pmos ad=1.125p pd=5u as=1.125p ps=5u w=4.5u l=9.5u
X382 bna_ bnb a_19700_200# avss sg13_hv_nmos ad=1.125p pd=5u as=1.125p ps=5u w=4.5u l=0.5u
X383 a_29300_1400# in_p yp_m avss sg13_hv_nmos ad=1.125p pd=5u as=1.125p ps=5u w=4.5u l=0.5u
X384 bpa_r bpb bpb avdd sg13_hv_pmos ad=1.125p pd=5u as=1.125p ps=5u w=4.5u l=0.5u
X385 xp in_p yn_m avdd sg13_hv_pmos ad=1.125p pd=5u as=1.125p ps=5u w=4.5u l=0.5u
X386 a_22100_200# bnb bnb avss sg13_hv_nmos ad=1.125p pd=5u as=1.125p ps=5u w=4.5u l=0.5u
X387 out zp_p avdd avdd sg13_hv_pmos ad=1.125p pd=5u as=1.125p ps=5u w=4.5u l=0.5u
X388 a_39700_1400# bnb zp_m avss sg13_hv_nmos ad=1.125p pd=5u as=1.125p ps=5u w=4.5u l=0.5u
X389 a_47900_200# zn_m yn_p avss sg13_hv_nmos ad=1.125p pd=5u as=1.125p ps=5u w=4.5u l=3.5u
X390 bnb bpa avdd avdd sg13_hv_pmos ad=1.125p pd=5u as=1.125p ps=5u w=4.5u l=3.5u
X391 zp_m bnb a_39300_200# avss sg13_hv_nmos ad=1.125p pd=5u as=1.125p ps=5u w=4.5u l=0.5u
X392 zn_m bpb a_43900_5000# avdd sg13_hv_pmos ad=1.125p pd=5u as=1.125p ps=5u w=4.5u l=0.5u
X393 avdd bpa xp avdd sg13_hv_pmos ad=1.125p pd=5u as=1.125p ps=5u w=4.5u l=3.5u
X394 bpa_l bpb bpb avdd sg13_hv_pmos ad=1.125p pd=5u as=1.125p ps=5u w=4.5u l=0.5u
X395 a_50500_200# zn_m yn_m avss sg13_hv_nmos ad=1.125p pd=5u as=1.125p ps=5u w=4.5u l=0.5u
X396 zn_p zn_m a_53700_1400# avss sg13_hv_nmos ad=1.125p pd=5u as=1.125p ps=5u w=4.5u l=0.5u
X397 zp_p bpb zn_p avdd sg13_hv_pmos ad=1.125p pd=5u as=1.125p ps=5u w=4.5u l=0.5u
X398 a_19300_1400# bnb bna_ avss sg13_hv_nmos ad=1.125p pd=5u as=1.125p ps=5u w=4.5u l=0.5u
X399 avss zn_p a_58100_1400# avss sg13_hv_nmos ad=1.125p pd=5u as=1.125p ps=5u w=4.5u l=0.5u
X400 ib en bna avss sg13_hv_nmos ad=1.125p pd=5u as=1.125p ps=5u w=4.5u l=1.5u
X401 a_30300_1400# bna xn avss sg13_hv_nmos ad=1.125p pd=5u as=1.125p ps=5u w=4.5u l=3.5u
X402 avss zn_p a_58900_200# avss sg13_hv_nmos ad=1.125p pd=5u as=1.125p ps=5u w=4.5u l=0.5u
X403 bpa_r bpb bpb avdd sg13_hv_pmos ad=1.125p pd=5u as=1.125p ps=5u w=4.5u l=0.5u
X404 out zp_p a_58700_6200# avdd sg13_hv_pmos ad=1.125p pd=5u as=1.125p ps=5u w=4.5u l=0.5u
X405 bna_ bnb a_22900_1400# avss sg13_hv_nmos ad=1.125p pd=5u as=1.125p ps=5u w=4.5u l=0.5u
X406 bpb bpb bpa_l avdd sg13_hv_pmos ad=1.125p pd=5u as=1.125p ps=5u w=4.5u l=0.5u
X407 bna_ bnb a_18100_200# avss sg13_hv_nmos ad=1.125p pd=5u as=1.125p ps=5u w=4.5u l=0.5u
X408 yp_m zp_m avdd avdd sg13_hv_pmos ad=1.125p pd=5u as=1.125p ps=5u w=4.5u l=3.5u
X409 zn_m bpb a_43900_5000# avdd sg13_hv_pmos ad=1.125p pd=5u as=1.125p ps=5u w=4.5u l=0.5u
X410 bpa_l bpb bpb avdd sg13_hv_pmos ad=1.125p pd=5u as=1.125p ps=5u w=4.5u l=0.5u
X411 a_55100_200# zn_m yn_m avss sg13_hv_nmos ad=1.125p pd=5u as=1.125p ps=5u w=4.5u l=3.5u
X412 zp_m zp_m yp_p avdd sg13_hv_pmos ad=1.125p pd=5u as=1.125p ps=5u w=4.5u l=0.5u
X413 bna_ bnb a_21300_200# avss sg13_hv_nmos ad=1.125p pd=5u as=1.125p ps=5u w=4.5u l=0.5u
X414 a_19700_1400# bnb bnb avss sg13_hv_nmos ad=1.125p pd=5u as=1.125p ps=5u w=4.5u l=0.5u
X415 zp_p zp_m yp_m avdd sg13_hv_pmos ad=1.125p pd=5u as=1.125p ps=5u w=4.5u l=0.5u
X416 out zn_p a_58500_1400# avss sg13_hv_nmos ad=1.125p pd=5u as=1.125p ps=5u w=4.5u l=0.5u
X417 zp_p en avdd avdd sg13_hv_pmos ad=1.125p pd=5u as=1.125p ps=5u w=4.5u l=1.5u
X418 zn_m zn_m a_46500_200# avss sg13_hv_nmos ad=1.125p pd=5u as=1.125p ps=5u w=4.5u l=0.5u
X419 yp_m zp_m avdd avdd sg13_hv_pmos ad=1.125p pd=5u as=1.125p ps=5u w=4.5u l=3.5u
X420 a_14300_200# bna bpb avss sg13_hv_nmos ad=1.125p pd=5u as=1.125p ps=5u w=4.5u l=3.5u
X421 bpa bna a_9500_200# avss sg13_hv_nmos ad=1.125p pd=5u as=1.125p ps=5u w=4.5u l=3.5u
X422 a_52100_1400# bnb zp_p avss sg13_hv_nmos ad=1.125p pd=5u as=1.125p ps=5u w=4.5u l=0.5u
X423 yp_p zp_m zp_m avdd sg13_hv_pmos ad=1.125p pd=5u as=1.125p ps=5u w=4.5u l=0.5u
X424 a_23500_1400# bna_ a_23300_1400# avss sg13_hv_nmos ad=1.125p pd=5u as=1.125p ps=5u w=4.5u l=0.5u
X425 avdd bpa bnb avdd sg13_hv_pmos ad=1.125p pd=5u as=1.125p ps=5u w=4.5u l=3.5u
X426 a_4700_1400# bna avss avss sg13_hv_nmos ad=1.125p pd=5u as=1.125p ps=5u w=4.5u l=3.5u
X427 bpb bpb bpa_l avdd sg13_hv_pmos ad=1.125p pd=5u as=1.125p ps=5u w=4.5u l=0.5u
X428 xp bpa avdd avdd sg13_hv_pmos ad=1.125p pd=5u as=1.125p ps=5u w=4.5u l=3.5u
X429 zp_m bnb a_40900_200# avss sg13_hv_nmos ad=1.125p pd=5u as=1.125p ps=5u w=4.5u l=0.5u
X430 a_4700_200# bna avss avss sg13_hv_nmos ad=1.125p pd=5u as=1.125p ps=5u w=4.5u l=3.5u
X431 bpb bpb bpa_r avdd sg13_hv_pmos ad=1.125p pd=5u as=1.125p ps=5u w=4.5u l=0.5u
X432 a_57100_6200# zp_p out avdd sg13_hv_pmos ad=1.125p pd=5u as=1.125p ps=5u w=4.5u l=0.5u
X433 zn_m bpb a_43900_5000# avdd sg13_hv_pmos ad=1.125p pd=5u as=1.125p ps=5u w=4.5u l=0.5u
X434 a_58500_200# zn_p avss avss sg13_hv_nmos ad=1.125p pd=5u as=1.125p ps=5u w=4.5u l=0.5u
X435 zp_m zp_m yp_p avdd sg13_hv_pmos ad=1.125p pd=5u as=1.125p ps=5u w=4.5u l=0.5u
X436 xp in_m yn_p avdd sg13_hv_pmos ad=1.125p pd=5u as=1.125p ps=5u w=4.5u l=0.5u
X437 avdd en zp_p avdd sg13_hv_pmos ad=2.25p pd=10u as=1.125p ps=5u w=4.5u l=1.5u
X438 bpb bpb bpa_l avdd sg13_hv_pmos ad=1.125p pd=5u as=1.125p ps=5u w=4.5u l=0.5u
X439 a_52500_1400# bnb zn_p avss sg13_hv_nmos ad=1.125p pd=5u as=1.125p ps=5u w=4.5u l=0.5u
X440 a_17700_200# bnb bna_ avss sg13_hv_nmos ad=1.125p pd=5u as=1.125p ps=5u w=4.5u l=0.5u
X441 a_23900_1400# bna_ a_23700_1400# avss sg13_hv_nmos ad=1.125p pd=5u as=1.125p ps=5u w=4.5u l=0.5u
X442 a_46700_5000# bpb zn_m avdd sg13_hv_pmos ad=1.125p pd=5u as=1.125p ps=5u w=4.5u l=0.5u
X443 yp_m in_p a_28100_1400# avss sg13_hv_nmos ad=1.125p pd=5u as=1.125p ps=5u w=4.5u l=0.5u
X444 zn_m zn_m a_44900_200# avss sg13_hv_nmos ad=1.125p pd=5u as=1.125p ps=5u w=4.5u l=0.5u
X445 bna enb avss avss sg13_hv_nmos ad=1.125p pd=5u as=1.125p ps=5u w=4.5u l=1.5u
X446 bpb bpb bpa_r avdd sg13_hv_pmos ad=1.125p pd=5u as=1.125p ps=5u w=4.5u l=0.5u
X447 zn_p zn_m a_53700_200# avss sg13_hv_nmos ad=1.125p pd=5u as=1.125p ps=5u w=4.5u l=0.5u
X448 a_12700_200# bna avss avss sg13_hv_nmos ad=1.125p pd=5u as=1.125p ps=5u w=4.5u l=3.5u
X449 avdd zp_p out avdd sg13_hv_pmos ad=1.125p pd=5u as=1.125p ps=5u w=4.5u l=0.5u
X450 zp_m zp_m yp_p avdd sg13_hv_pmos ad=1.125p pd=5u as=1.125p ps=5u w=4.5u l=0.5u
X451 a_20900_200# bnb bna_ avss sg13_hv_nmos ad=1.125p pd=5u as=1.125p ps=5u w=4.5u l=0.5u
X452 avdd zp_m yp_m avdd sg13_hv_pmos ad=1.125p pd=5u as=1.125p ps=5u w=4.5u l=3.5u
X453 yn_p zn_m a_31900_1400# avss sg13_hv_nmos ad=1.125p pd=5u as=1.125p ps=5u w=4.5u l=3.5u
X454 zp_p zp_m yp_m avdd sg13_hv_pmos ad=1.125p pd=5u as=1.125p ps=5u w=4.5u l=0.5u
X455 xn in_p a_29300_200# avss sg13_hv_nmos ad=1.125p pd=5u as=1.125p ps=5u w=4.5u l=0.5u
X456 avss bna a_42300_1400# avss sg13_hv_nmos ad=1.125p pd=5u as=1.125p ps=5u w=4.5u l=3.5u
X457 xp in_m yn_p avdd sg13_hv_pmos ad=1.125p pd=5u as=1.125p ps=5u w=4.5u l=0.5u
X458 bpb bpb bpa_l avdd sg13_hv_pmos ad=1.125p pd=5u as=1.125p ps=5u w=4.5u l=0.5u
X459 a_40500_200# bnb zp_m avss sg13_hv_nmos ad=1.125p pd=5u as=1.125p ps=5u w=4.5u l=0.5u
X460 a_52900_1400# bnb zp_p avss sg13_hv_nmos ad=1.125p pd=5u as=1.125p ps=5u w=4.5u l=0.5u
X461 yp_m zp_m zp_p avdd sg13_hv_pmos ad=1.125p pd=5u as=1.125p ps=5u w=4.5u l=0.5u
X462 a_57300_1400# zn_p out avss sg13_hv_nmos ad=1.125p pd=5u as=1.125p ps=5u w=4.5u l=0.5u
X463 bna_ bnb a_18100_1400# avss sg13_hv_nmos ad=1.125p pd=5u as=1.125p ps=5u w=4.5u l=0.5u
X464 yp_p zp_m avdd avdd sg13_hv_pmos ad=1.125p pd=5u as=1.125p ps=5u w=4.5u l=3.5u
X465 a_46700_5000# bpb zn_m avdd sg13_hv_pmos ad=1.125p pd=5u as=1.125p ps=5u w=4.5u l=0.5u
X466 bna bna a_4700_1400# avss sg13_hv_nmos ad=1.125p pd=5u as=1.125p ps=5u w=4.5u l=3.5u
X467 xn in_p a_28500_1400# avss sg13_hv_nmos ad=1.125p pd=5u as=1.125p ps=5u w=4.5u l=0.5u
X468 bpb bpb bpa_r avdd sg13_hv_pmos ad=1.125p pd=5u as=1.125p ps=5u w=4.5u l=0.5u
X469 out zn_p a_57700_200# avss sg13_hv_nmos ad=1.125p pd=5u as=1.125p ps=5u w=4.5u l=0.5u
X470 a_16100_200# bna_ a_15900_200# avss sg13_hv_nmos ad=1.125p pd=5u as=1.125p ps=5u w=4.5u l=0.5u
X471 a_22100_1400# bnb bnb avss sg13_hv_nmos ad=1.125p pd=5u as=1.125p ps=5u w=4.5u l=0.5u
X472 a_57900_6200# zp_p out avdd sg13_hv_pmos ad=1.125p pd=5u as=1.125p ps=5u w=4.5u l=0.5u
X473 a_25500_200# bna avss avss sg13_hv_nmos ad=1.125p pd=5u as=1.125p ps=5u w=4.5u l=3.5u
X474 a_12300_6200# bpa_l a_12100_6200# avdd sg13_hv_pmos ad=1.125p pd=5u as=1.125p ps=5u w=4.5u l=0.5u
X475 avdd zp_m yp_p avdd sg13_hv_pmos ad=1.125p pd=5u as=1.125p ps=5u w=4.5u l=3.5u
X476 zp_p zp_m yp_m avdd sg13_hv_pmos ad=1.125p pd=5u as=1.125p ps=5u w=4.5u l=0.5u
X477 xp in_m yn_p avdd sg13_hv_pmos ad=1.125p pd=5u as=1.125p ps=5u w=4.5u l=0.5u
X478 zn_p bnb a_52100_200# avss sg13_hv_nmos ad=1.125p pd=5u as=1.125p ps=5u w=4.5u l=0.5u
X479 enb en avdd avdd sg13_hv_pmos ad=1.125p pd=5u as=2.25p ps=10u w=4.5u l=1.5u
X480 a_47900_1400# zn_m yn_p avss sg13_hv_nmos ad=1.125p pd=5u as=1.125p ps=5u w=4.5u l=3.5u
X481 bpb bpb bpa_l avdd sg13_hv_pmos ad=1.125p pd=5u as=1.125p ps=5u w=4.5u l=0.5u
X482 zn_p bpb zp_p avdd sg13_hv_pmos ad=1.125p pd=5u as=1.125p ps=5u w=4.5u l=0.5u
X483 bpb bpb bpa_r avdd sg13_hv_pmos ad=1.125p pd=5u as=1.125p ps=5u w=4.5u l=0.5u
X484 bnb bnb a_18500_1400# avss sg13_hv_nmos ad=1.125p pd=5u as=1.125p ps=5u w=4.5u l=0.5u
X485 a_57700_1400# zn_p avss avss sg13_hv_nmos ad=1.125p pd=5u as=1.125p ps=5u w=4.5u l=0.5u
X486 avdd zp_p out avdd sg13_hv_pmos ad=1.125p pd=5u as=1.125p ps=5u w=4.5u l=0.5u
X487 a_46700_5000# bpb zn_m avdd sg13_hv_pmos ad=1.125p pd=5u as=1.125p ps=5u w=4.5u l=0.5u
X488 a_12700_1400# bna avss avss sg13_hv_nmos ad=1.125p pd=5u as=1.125p ps=5u w=4.5u l=3.5u
X489 yp_m zp_m avdd avdd sg13_hv_pmos ad=1.125p pd=5u as=1.125p ps=5u w=4.5u l=3.5u
X490 yn_m zn_m a_50900_1400# avss sg13_hv_nmos ad=1.125p pd=5u as=1.125p ps=5u w=4.5u l=0.5u
X491 zp_m zp_m yp_p avdd sg13_hv_pmos ad=1.125p pd=5u as=1.125p ps=5u w=4.5u l=0.5u
X492 bpa bna a_9500_1400# avss sg13_hv_nmos ad=1.125p pd=5u as=1.125p ps=5u w=4.5u l=3.5u
X493 a_28900_200# in_p xn avss sg13_hv_nmos ad=1.125p pd=5u as=1.125p ps=5u w=4.5u l=0.5u
X494 a_22500_1400# bnb bna_ avss sg13_hv_nmos ad=1.125p pd=5u as=1.125p ps=5u w=4.5u l=0.5u
X495 bpa_l bpa_l a_12500_6200# avdd sg13_hv_pmos ad=1.125p pd=5u as=1.125p ps=5u w=4.5u l=0.5u
X496 avdd zp_m yp_m avdd sg13_hv_pmos ad=1.125p pd=5u as=1.125p ps=5u w=4.5u l=3.5u
X497 a_17100_6200# bpa_r a_16900_6200# avdd sg13_hv_pmos ad=1.125p pd=5u as=1.125p ps=5u w=4.5u l=0.5u
X498 xp in_m yn_p avdd sg13_hv_pmos ad=1.125p pd=5u as=1.125p ps=5u w=4.5u l=0.5u
X499 a_33500_1400# zn_m yn_p avss sg13_hv_nmos ad=1.125p pd=5u as=1.125p ps=5u w=4.5u l=3.5u
X500 out zp_p avdd avdd sg13_hv_pmos ad=1.125p pd=5u as=1.125p ps=5u w=4.5u l=0.5u
X501 avdd en enb avdd sg13_hv_pmos ad=1.125p pd=5u as=1.125p ps=5u w=4.5u l=1.5u
X502 out zn_p a_56100_200# avss sg13_hv_nmos ad=1.125p pd=5u as=1.125p ps=5u w=4.5u l=0.5u
X503 a_23300_200# bna_ bna_ avss sg13_hv_nmos ad=1.125p pd=5u as=1.125p ps=5u w=4.5u l=0.5u
X504 bpa en avdd avdd sg13_hv_pmos ad=1.125p pd=5u as=1.125p ps=5u w=4.5u l=1.5u
X505 a_15500_200# bna_ a_15300_200# avss sg13_hv_nmos ad=1.125p pd=5u as=1.125p ps=5u w=4.5u l=0.5u
X506 zp_m bnb a_40900_1400# avss sg13_hv_nmos ad=1.125p pd=5u as=1.125p ps=5u w=4.5u l=0.5u
X507 bpb bpb bpa_r avdd sg13_hv_pmos ad=1.125p pd=5u as=1.125p ps=5u w=4.5u l=0.5u
X508 avdd zp_p out avdd sg13_hv_pmos ad=1.125p pd=5u as=1.125p ps=5u w=4.5u l=0.5u
X509 xp bpa avdd avdd sg13_hv_pmos ad=1.125p pd=5u as=1.125p ps=5u w=4.5u l=3.5u
X510 bpa_l bpb bpb avdd sg13_hv_pmos ad=1.125p pd=5u as=1.125p ps=5u w=4.5u l=0.5u
X511 zn_p zn_m a_51300_1400# avss sg13_hv_nmos ad=1.125p pd=5u as=1.125p ps=5u w=4.5u l=0.5u
X512 zp_m zp_m yp_p avdd sg13_hv_pmos ad=1.125p pd=5u as=1.125p ps=5u w=4.5u l=0.5u
X513 a_51700_200# bnb zn_p avss sg13_hv_nmos ad=1.125p pd=5u as=1.125p ps=5u w=4.5u l=0.5u
X514 a_22900_1400# bnb bnb avss sg13_hv_nmos ad=1.125p pd=5u as=1.125p ps=5u w=4.5u l=0.5u
X515 a_46700_5000# bpa avdd avdd sg13_hv_pmos ad=1.125p pd=5u as=1.125p ps=5u w=4.5u l=3.5u
X516 tihi tihi avdd avdd sg13_hv_pmos ad=1.125p pd=5u as=1.125p ps=5u w=4.5u l=9.5u
X517 a_27300_1400# in_m xn avss sg13_hv_nmos ad=1.125p pd=5u as=1.125p ps=5u w=4.5u l=0.5u
X518 bpa_r bpa_r a_17300_6200# avdd sg13_hv_pmos ad=1.125p pd=5u as=1.125p ps=5u w=4.5u l=0.5u
X519 out zp_p a_56300_6200# avdd sg13_hv_pmos ad=1.125p pd=5u as=1.125p ps=5u w=4.5u l=0.5u
X520 a_38300_1400# bna avss avss sg13_hv_nmos ad=1.125p pd=5u as=1.125p ps=5u w=4.5u l=3.5u
X521 a_27300_200# in_m xn avss sg13_hv_nmos ad=1.125p pd=5u as=1.125p ps=5u w=4.5u l=0.5u
X522 avdd en bpa avdd sg13_hv_pmos ad=1.125p pd=5u as=1.125p ps=5u w=4.5u l=1.5u
X523 a_21300_6200# bpa_r a_21100_6200# avdd sg13_hv_pmos ad=1.125p pd=5u as=1.125p ps=5u w=4.5u l=0.5u
X524 bnb bnb a_19300_200# avss sg13_hv_nmos ad=1.125p pd=5u as=1.125p ps=5u w=4.5u l=0.5u
X525 a_39100_200# bnb a_41300_1400# avss sg13_hv_nmos ad=1.125p pd=5u as=1.125p ps=5u w=4.5u l=0.5u
X526 zp_m zp_m yp_p avdd sg13_hv_pmos ad=1.125p pd=5u as=1.125p ps=5u w=4.5u l=0.5u
X527 bpa_l bpb bpb avdd sg13_hv_pmos ad=1.125p pd=5u as=1.125p ps=5u w=4.5u l=0.5u
X528 avss bna a_30300_200# avss sg13_hv_nmos ad=1.125p pd=5u as=1.125p ps=5u w=4.5u l=3.5u
X529 zp_p bnb a_51700_1400# avss sg13_hv_nmos ad=1.125p pd=5u as=1.125p ps=5u w=4.5u l=0.5u
X530 bpb bna a_12700_1400# avss sg13_hv_nmos ad=1.125p pd=5u as=1.125p ps=5u w=4.5u l=3.5u
X531 yn_m in_p xp avdd sg13_hv_pmos ad=1.125p pd=5u as=1.125p ps=5u w=4.5u l=0.5u
X532 a_17300_1400# bnb bnb avss sg13_hv_nmos ad=1.125p pd=5u as=1.125p ps=5u w=4.5u l=0.5u
X533 yp_m zp_m avdd avdd sg13_hv_pmos ad=1.125p pd=5u as=1.125p ps=5u w=4.5u l=3.5u
X534 out zn_p a_56100_1400# avss sg13_hv_nmos ad=1.125p pd=5u as=1.125p ps=5u w=4.5u l=0.5u
X535 bnb bnb a_22500_200# avss sg13_hv_nmos ad=1.125p pd=5u as=1.125p ps=5u w=4.5u l=0.5u
X536 a_27700_1400# in_m yp_p avss sg13_hv_nmos ad=1.125p pd=5u as=1.125p ps=5u w=4.5u l=0.5u
X537 bpa_r bpb bpb avdd sg13_hv_pmos ad=1.125p pd=5u as=1.125p ps=5u w=4.5u l=0.5u
X538 bnb bnb a_20900_1400# avss sg13_hv_nmos ad=1.125p pd=5u as=1.125p ps=5u w=4.5u l=0.5u
X539 out zp_p avdd avdd sg13_hv_pmos ad=1.125p pd=5u as=1.125p ps=5u w=4.5u l=0.5u
X540 yp_p zp_m zp_m avdd sg13_hv_pmos ad=1.125p pd=5u as=1.125p ps=5u w=4.5u l=0.5u
X541 avdd bpa bpa avdd sg13_hv_pmos ad=1.125p pd=5u as=1.125p ps=5u w=4.5u l=3.5u
X542 zn_p bpb zp_p avdd sg13_hv_pmos ad=1.125p pd=5u as=1.125p ps=5u w=4.5u l=0.5u
X543 yn_p in_m xp avdd sg13_hv_pmos ad=1.125p pd=5u as=1.125p ps=5u w=4.5u l=0.5u
X544 bpa bpa avdd avdd sg13_hv_pmos ad=1.125p pd=5u as=1.125p ps=5u w=4.5u l=3.5u
X545 bnb bpa avdd avdd sg13_hv_pmos ad=1.125p pd=5u as=1.125p ps=5u w=4.5u l=3.5u
X546 avdd zp_m yp_p avdd sg13_hv_pmos ad=1.125p pd=5u as=1.125p ps=5u w=4.5u l=3.5u
X547 yn_p zn_m a_46100_1400# avss sg13_hv_nmos ad=1.125p pd=5u as=1.125p ps=5u w=4.5u l=0.5u
X548 bpa_l bpb bpb avdd sg13_hv_pmos ad=1.125p pd=5u as=1.125p ps=5u w=4.5u l=0.5u
X549 a_35100_200# zn_m avss avss sg13_hv_nmos ad=1.125p pd=5u as=1.125p ps=5u w=4.5u l=3.5u
X550 yn_m in_p xp avdd sg13_hv_pmos ad=1.125p pd=5u as=1.125p ps=5u w=4.5u l=0.5u
X551 bpa_r bpb bpb avdd sg13_hv_pmos ad=1.125p pd=5u as=1.125p ps=5u w=4.5u l=0.5u
X552 avss zn_p a_56500_1400# avss sg13_hv_nmos ad=1.125p pd=5u as=1.125p ps=5u w=4.5u l=0.5u
X553 a_17700_1400# bnb bna_ avss sg13_hv_nmos ad=1.125p pd=5u as=1.125p ps=5u w=4.5u l=0.5u
X554 avss enb zn_p avss sg13_hv_nmos ad=2.25p pd=10u as=1.125p ps=5u w=4.5u l=1.5u
X555 yp_p in_m a_26500_200# avss sg13_hv_nmos ad=1.125p pd=5u as=1.125p ps=5u w=4.5u l=0.5u
X556 out zp_p avdd avdd sg13_hv_pmos ad=1.125p pd=5u as=1.125p ps=5u w=4.5u l=0.5u
X557 zn_m bpb a_46700_5000# avdd sg13_hv_pmos ad=1.125p pd=5u as=1.125p ps=5u w=4.5u l=0.5u
X558 bna_ bnb a_21300_1400# avss sg13_hv_nmos ad=1.125p pd=5u as=1.125p ps=5u w=4.5u l=0.5u
X559 a_18900_200# bnb bnb avss sg13_hv_nmos ad=1.125p pd=5u as=1.125p ps=5u w=4.5u l=0.5u
X560 a_54100_200# zn_m zn_p avss sg13_hv_nmos ad=1.125p pd=5u as=1.125p ps=5u w=4.5u l=0.5u
X561 zn_p bpb zp_p avdd sg13_hv_pmos ad=1.125p pd=5u as=1.125p ps=5u w=4.5u l=0.5u
X562 bnb bnb a_20900_200# avss sg13_hv_nmos ad=1.125p pd=5u as=1.125p ps=5u w=4.5u l=0.5u
X563 a_16100_6200# bpa_l bpa_l avdd sg13_hv_pmos ad=1.125p pd=5u as=1.125p ps=5u w=4.5u l=0.5u
X564 yp_m zp_m zp_p avdd sg13_hv_pmos ad=1.125p pd=5u as=1.125p ps=5u w=4.5u l=0.5u
X565 yn_p in_m xp avdd sg13_hv_pmos ad=1.125p pd=5u as=1.125p ps=5u w=4.5u l=0.5u
X566 yn_p zn_m a_46100_200# avss sg13_hv_nmos ad=1.125p pd=5u as=1.125p ps=5u w=4.5u l=0.5u
X567 yp_p zp_m avdd avdd sg13_hv_pmos ad=1.125p pd=5u as=1.125p ps=5u w=4.5u l=3.5u
X568 a_39100_200# bna a_38300_200# avss sg13_hv_nmos ad=1.125p pd=5u as=1.125p ps=5u w=4.5u l=3.5u
X569 zn_m zn_m a_46500_1400# avss sg13_hv_nmos ad=1.125p pd=5u as=1.125p ps=5u w=4.5u l=0.5u
X570 zn_m bpb a_46700_5000# avdd sg13_hv_pmos ad=1.125p pd=5u as=1.125p ps=5u w=4.5u l=0.5u
X571 avdd bpa xp avdd sg13_hv_pmos ad=1.125p pd=5u as=1.125p ps=5u w=4.5u l=3.5u
X572 bpa_r bpb bpb avdd sg13_hv_pmos ad=1.125p pd=5u as=1.125p ps=5u w=4.5u l=0.5u
X573 a_40100_1400# bnb a_39100_200# avss sg13_hv_nmos ad=1.125p pd=5u as=1.125p ps=5u w=4.5u l=0.5u
X574 out zp_p avdd avdd sg13_hv_pmos ad=1.125p pd=5u as=1.125p ps=5u w=4.5u l=0.5u
X575 a_12100_5000# bpa_l avdd avdd sg13_hv_pmos ad=1.125p pd=5u as=1.125p ps=5u w=4.5u l=0.5u
X576 a_50500_1400# zn_m yn_m avss sg13_hv_nmos ad=1.125p pd=5u as=1.125p ps=5u w=4.5u l=0.5u
X577 yp_m zp_m zp_p avdd sg13_hv_pmos ad=1.125p pd=5u as=1.125p ps=5u w=4.5u l=0.5u
X578 avdd bpa bpa avdd sg13_hv_pmos ad=1.125p pd=5u as=1.125p ps=5u w=4.5u l=3.5u
X579 a_42300_200# bna a_39100_200# avss sg13_hv_nmos ad=1.125p pd=5u as=1.125p ps=5u w=4.5u l=3.5u
X580 avdd bpa bnb avdd sg13_hv_pmos ad=1.125p pd=5u as=1.125p ps=5u w=4.5u l=3.5u
X581 bnb bnb a_21700_1400# avss sg13_hv_nmos ad=1.125p pd=5u as=1.125p ps=5u w=4.5u l=0.5u
X582 a_43900_5000# bpb zn_m avdd sg13_hv_pmos ad=1.125p pd=5u as=1.125p ps=5u w=4.5u l=0.5u
X583 a_58100_200# zn_p out avss sg13_hv_nmos ad=1.125p pd=5u as=1.125p ps=5u w=4.5u l=0.5u
X584 a_16500_6200# bpa_l a_16300_6200# avdd sg13_hv_pmos ad=1.125p pd=5u as=1.125p ps=5u w=4.5u l=0.5u
X585 yn_p in_m xp avdd sg13_hv_pmos ad=1.125p pd=5u as=1.125p ps=5u w=4.5u l=0.5u
X586 a_17300_200# bnb bnb avss sg13_hv_nmos ad=1.125p pd=5u as=1.125p ps=5u w=4.5u l=0.5u
X587 zn_m bpb a_46700_5000# avdd sg13_hv_pmos ad=1.125p pd=5u as=1.125p ps=5u w=4.5u l=0.5u
X588 bpa_r bpb bpb avdd sg13_hv_pmos ad=1.125p pd=5u as=1.125p ps=5u w=4.5u l=0.5u
X589 a_40500_1400# bnb zp_m avss sg13_hv_nmos ad=1.125p pd=5u as=1.125p ps=5u w=4.5u l=0.5u
X590 yn_m zn_m a_53300_200# avss sg13_hv_nmos ad=1.125p pd=5u as=1.125p ps=5u w=4.5u l=0.5u
X591 a_20500_200# bnb bnb avss sg13_hv_nmos ad=1.125p pd=5u as=1.125p ps=5u w=4.5u l=0.5u
X592 a_12500_5000# bpa_l a_12300_5000# avdd sg13_hv_pmos ad=1.125p pd=5u as=1.125p ps=5u w=4.5u l=0.5u
X593 a_50900_1400# zn_m zn_p avss sg13_hv_nmos ad=1.125p pd=5u as=1.125p ps=5u w=4.5u l=0.5u
X594 yp_m zp_m zp_p avdd sg13_hv_pmos ad=1.125p pd=5u as=1.125p ps=5u w=4.5u l=0.5u
X595 a_16300_1400# bna_ a_16100_1400# avss sg13_hv_nmos ad=1.125p pd=5u as=1.125p ps=5u w=4.5u l=0.5u
X596 a_45700_200# zn_m yn_p avss sg13_hv_nmos ad=1.125p pd=5u as=1.125p ps=5u w=4.5u l=0.5u
X597 avss zn_m a_55100_1400# avss sg13_hv_nmos ad=1.125p pd=5u as=1.125p ps=5u w=4.5u l=3.5u
X598 avdd zp_m yp_p avdd sg13_hv_pmos ad=1.125p pd=5u as=1.125p ps=5u w=4.5u l=3.5u
X599 yp_m in_p a_28900_200# avss sg13_hv_nmos ad=1.125p pd=5u as=1.125p ps=5u w=4.5u l=0.5u
X600 yp_p in_m a_26500_1400# avss sg13_hv_nmos ad=1.125p pd=5u as=1.125p ps=5u w=4.5u l=0.5u
X601 a_16900_6200# bpa_r avdd avdd sg13_hv_pmos ad=1.125p pd=5u as=1.125p ps=5u w=4.5u l=0.5u
X602 avss bna a_7100_1400# avss sg13_hv_nmos ad=1.125p pd=5u as=1.125p ps=5u w=4.5u l=3.5u
X603 a_20100_1400# bnb bna_ avss sg13_hv_nmos ad=1.125p pd=5u as=1.125p ps=5u w=4.5u l=0.5u
X604 yp_p zp_m avdd avdd sg13_hv_pmos ad=1.125p pd=5u as=1.125p ps=5u w=4.5u l=3.5u
X605 a_40100_200# bnb a_39100_200# avss sg13_hv_nmos ad=1.125p pd=5u as=1.125p ps=5u w=4.5u l=0.5u
X606 avss bna a_30300_1400# avss sg13_hv_nmos ad=1.125p pd=5u as=1.125p ps=5u w=4.5u l=3.5u
X607 bpa_r bpb bpb avdd sg13_hv_pmos ad=1.125p pd=5u as=1.125p ps=5u w=4.5u l=0.5u
X608 a_40900_1400# bnb a_39100_200# avss sg13_hv_nmos ad=1.125p pd=5u as=1.125p ps=5u w=4.5u l=0.5u
X609 yp_p zp_m zp_m avdd sg13_hv_pmos ad=1.125p pd=5u as=1.125p ps=5u w=4.5u l=0.5u
X610 avss zn_p a_57300_200# avss sg13_hv_nmos ad=1.125p pd=5u as=1.125p ps=5u w=4.5u l=0.5u
X611 a_45300_1400# zn_m zn_m avss sg13_hv_nmos ad=1.125p pd=5u as=1.125p ps=5u w=4.5u l=0.5u
X612 bpb bpb bpa_l avdd sg13_hv_pmos ad=1.125p pd=5u as=1.125p ps=5u w=4.5u l=0.5u
X613 a_24500_200# bna_ a_24300_200# avss sg13_hv_nmos ad=1.125p pd=5u as=1.125p ps=5u w=4.5u l=0.5u
X614 xp in_p yn_m avdd sg13_hv_pmos ad=1.125p pd=5u as=1.125p ps=5u w=4.5u l=0.5u
X615 bna_ bna_ a_16500_1400# avss sg13_hv_nmos ad=1.125p pd=5u as=1.125p ps=5u w=4.5u l=0.5u
X616 a_17300_5000# bpa_r a_17100_5000# avdd sg13_hv_pmos ad=1.125p pd=5u as=1.125p ps=5u w=4.5u l=0.5u
X617 yn_m zn_m a_49500_200# avss sg13_hv_nmos ad=1.125p pd=5u as=1.125p ps=5u w=4.5u l=3.5u
X618 avdd zp_p out avdd sg13_hv_pmos ad=1.125p pd=5u as=1.125p ps=5u w=4.5u l=0.5u
X619 bna_ bna_ a_16500_200# avss sg13_hv_nmos ad=1.125p pd=5u as=1.125p ps=5u w=4.5u l=0.5u
X620 a_21100_5000# bpa_r a_20900_5000# avdd sg13_hv_pmos ad=1.125p pd=5u as=1.125p ps=5u w=4.5u l=0.5u
X621 a_20500_1400# bnb bnb avss sg13_hv_nmos ad=1.125p pd=5u as=1.125p ps=5u w=4.5u l=0.5u
X622 yn_p zn_m a_43900_200# avss sg13_hv_nmos ad=1.125p pd=5u as=1.125p ps=5u w=4.5u l=3.5u
X623 a_52900_200# bnb zp_p avss sg13_hv_nmos ad=1.125p pd=5u as=1.125p ps=5u w=4.5u l=0.5u
X624 bpa_l bpb bpb avdd sg13_hv_pmos ad=1.125p pd=5u as=1.125p ps=5u w=4.5u l=0.5u
X625 zp_p bpb zn_p avdd sg13_hv_pmos ad=1.125p pd=5u as=1.125p ps=5u w=4.5u l=0.5u
X626 yn_m zn_m a_35100_1400# avss sg13_hv_nmos ad=1.125p pd=5u as=1.125p ps=5u w=4.5u l=3.5u
X627 yp_p zp_m zp_m avdd sg13_hv_pmos ad=1.125p pd=5u as=1.125p ps=5u w=4.5u l=0.5u
X628 avdd tihi tihi avdd sg13_hv_pmos ad=1.125p pd=5u as=1.125p ps=5u w=4.5u l=9.5u
X629 a_45700_1400# zn_m yn_p avss sg13_hv_nmos ad=1.125p pd=5u as=1.125p ps=5u w=4.5u l=0.5u
X630 a_28500_200# in_p yp_m avss sg13_hv_nmos ad=1.125p pd=5u as=1.125p ps=5u w=4.5u l=0.5u
X631 xp in_p yn_m avdd sg13_hv_pmos ad=1.125p pd=5u as=1.125p ps=5u w=4.5u l=0.5u
X632 bpb bpb bpa_r avdd sg13_hv_pmos ad=1.125p pd=5u as=1.125p ps=5u w=4.5u l=0.5u
X633 a_11100_1400# bna bpa avss sg13_hv_nmos ad=1.125p pd=5u as=1.125p ps=5u w=4.5u l=3.5u
X634 avdd zp_p out avdd sg13_hv_pmos ad=1.125p pd=5u as=1.125p ps=5u w=4.5u l=0.5u
X635 zp_p zp_m yp_m avdd sg13_hv_pmos ad=1.125p pd=5u as=1.125p ps=5u w=4.5u l=0.5u
X636 a_20900_1400# bnb bna_ avss sg13_hv_nmos ad=1.125p pd=5u as=1.125p ps=5u w=4.5u l=0.5u
X637 zn_m bpb a_43900_5000# avdd sg13_hv_pmos ad=1.125p pd=5u as=1.125p ps=5u w=4.5u l=0.5u
X638 avdd bpa_r a_21300_5000# avdd sg13_hv_pmos ad=1.125p pd=5u as=1.125p ps=5u w=4.5u l=0.5u
X639 avss zn_m a_47900_200# avss sg13_hv_nmos ad=1.125p pd=5u as=1.125p ps=5u w=4.5u l=3.5u
X640 a_56900_200# zn_p avss avss sg13_hv_nmos ad=1.125p pd=5u as=1.125p ps=5u w=4.5u l=0.5u
X641 a_23900_200# bna_ a_23700_200# avss sg13_hv_nmos ad=1.125p pd=5u as=1.125p ps=5u w=4.5u l=0.5u
X642 bpa_l bpb bpb avdd sg13_hv_pmos ad=1.125p pd=5u as=1.125p ps=5u w=4.5u l=0.5u
X643 zp_p bpb zn_p avdd sg13_hv_pmos ad=1.125p pd=5u as=1.125p ps=5u w=4.5u l=0.5u
X644 xp in_p yn_m avdd sg13_hv_pmos ad=1.125p pd=5u as=1.125p ps=5u w=4.5u l=0.5u
X645 a_51300_200# zn_m yn_m avss sg13_hv_nmos ad=1.125p pd=5u as=1.125p ps=5u w=4.5u l=0.5u
X646 a_7100_200# bna bna avss sg13_hv_nmos ad=1.125p pd=5u as=1.125p ps=5u w=4.5u l=3.5u
X647 a_11100_200# bna bpa avss sg13_hv_nmos ad=1.125p pd=5u as=1.125p ps=5u w=4.5u l=3.5u
X648 a_15300_1400# bna_ avss avss sg13_hv_nmos ad=1.125p pd=5u as=1.125p ps=5u w=4.5u l=0.5u
X649 zp_p bpb zn_p avdd sg13_hv_pmos ad=1.125p pd=5u as=1.125p ps=5u w=4.5u l=0.5u
X650 yn_m zn_m a_54100_1400# avss sg13_hv_nmos ad=1.125p pd=5u as=1.125p ps=5u w=4.5u l=0.5u
X651 zn_m bpb a_43900_5000# avdd sg13_hv_pmos ad=1.125p pd=5u as=1.125p ps=5u w=4.5u l=0.5u
X652 xn bna a_25500_1400# avss sg13_hv_nmos ad=1.125p pd=5u as=1.125p ps=5u w=4.5u l=3.5u
X653 bna_ bnb a_18900_200# avss sg13_hv_nmos ad=1.125p pd=5u as=1.125p ps=5u w=4.5u l=0.5u
X654 bpa_l bpb bpb avdd sg13_hv_pmos ad=1.125p pd=5u as=1.125p ps=5u w=4.5u l=0.5u
X655 xn in_m a_27700_200# avss sg13_hv_nmos ad=1.125p pd=5u as=1.125p ps=5u w=4.5u l=0.5u
X656 zp_p zp_m yp_m avdd sg13_hv_pmos ad=1.125p pd=5u as=1.125p ps=5u w=4.5u l=0.5u
X657 xp in_p yn_m avdd sg13_hv_pmos ad=1.125p pd=5u as=1.125p ps=5u w=4.5u l=0.5u
X658 zp_p en avdd avdd sg13_hv_pmos ad=1.125p pd=5u as=1.125p ps=5u w=4.5u l=1.5u
X659 avss zn_m a_55100_200# avss sg13_hv_nmos ad=1.125p pd=5u as=1.125p ps=5u w=4.5u l=3.5u
X660 bna_ bnb a_22100_200# avss sg13_hv_nmos ad=1.125p pd=5u as=1.125p ps=5u w=4.5u l=0.5u
X661 avdd bpa bnb avdd sg13_hv_pmos ad=1.125p pd=5u as=1.125p ps=5u w=4.5u l=3.5u
X662 yp_p zp_m avdd avdd sg13_hv_pmos ad=1.125p pd=5u as=1.125p ps=5u w=4.5u l=3.5u
X663 avss bna a_14300_200# avss sg13_hv_nmos ad=1.125p pd=5u as=1.125p ps=5u w=4.5u l=3.5u
.ends

.subckt lpopamp_core zn_p out inm ib zp_p inp en avdd SUB
XsliceB_1 inm inp out SUB avdd ib en zp_p zn_p lpopamp_sliceB
XsliceA_0 inm inp out SUB avdd ib en zp_p zn_p lpopamp_sliceA
XsliceA_1 inm inp out SUB avdd ib en zp_p zn_p lpopamp_sliceA
XsliceB_0 inm inp out SUB avdd ib en zp_p zn_p lpopamp_sliceB
.ends

.subckt lpopamp en avdd inp SUB inm out ib
Xlpopamp_core_0 zn_p out inm ib zp_p inp en avdd SUB lpopamp_core
.ends

.subckt slot10_wrapper s10_an[0] s10_an[1] s10_an[2] s10_an_0_esd s10_an_1_esd s10_an_2_esd
+ vbias dig_in[23] dig_in[22] dig_in[21] dig_in[20] dig_in[19] dig_in[18] dig_in[17]
+ dig_in[16] dig_in[15] dig_in[14] dig_in[13] dig_in[12] dig_in[11] dig_in[10] dig_in[9]
+ dig_in[8] dig_in[7] dig_in[6] dig_in[5] dig_in[4] dig_in[3] dig_in[2] dig_in[1]
+ dig_in[0] dig_out[11] dig_out[10] dig_out[9] dig_out[8] dig_out[7] dig_out[6] dig_out[5]
+ dig_out[4] dig_out[3] dig_out[2] dig_out[1] dig_out[0] ibias0 ibias1 analog_bus3
+ analog_bus2 analog_bus1 analog_bus0 vss_1v2 vdd_1v2 vss_3v3 vdd_3v3 enable clk reset
Xlpopamp_0 lpopamp_0/en avdd inp SUB inm out ib lpopamp
R0 out s10_an[1] 0.012571
R1 out s10_an[1] 0.012571
R2 ibias0 ib 0.029333
R3 inp s10_an[0] 0.001833
R4 vss_3v3 SUB 0.000300
R5 out s10_an[1] 0.012571
R6 inm s10_an[2] 0.001833
R7 vdd_3v3 avdd 0.000300
R8 out s10_an[1] 0.012571
.ends
